* NGSPICE file created from mac_engine_2.ext - technology: sky130A

* Black-box entry subcircuit for sky130_fd_sc_hd__decap_4 abstract view
.subckt sky130_fd_sc_hd__decap_4 VGND VNB VPB VPWR
.ends

* Black-box entry subcircuit for sky130_fd_sc_hd__xor2_1 abstract view
.subckt sky130_fd_sc_hd__xor2_1 A B VGND VNB VPB VPWR X
.ends

* Black-box entry subcircuit for sky130_ef_sc_hd__decap_12 abstract view
.subckt sky130_ef_sc_hd__decap_12 VPWR VGND VPB VNB
.ends

* Black-box entry subcircuit for sky130_fd_sc_hd__and3_1 abstract view
.subckt sky130_fd_sc_hd__and3_1 A B C VGND VNB VPB VPWR X
.ends

* Black-box entry subcircuit for sky130_fd_sc_hd__fill_2 abstract view
.subckt sky130_fd_sc_hd__fill_2 VGND VNB VPB VPWR
.ends

* Black-box entry subcircuit for sky130_fd_sc_hd__tapvpwrvgnd_1 abstract view
.subckt sky130_fd_sc_hd__tapvpwrvgnd_1 VGND VPWR
.ends

* Black-box entry subcircuit for sky130_fd_sc_hd__diode_2 abstract view
.subckt sky130_fd_sc_hd__diode_2 DIODE VGND VNB VPB VPWR
.ends

* Black-box entry subcircuit for sky130_fd_sc_hd__mux2_1 abstract view
.subckt sky130_fd_sc_hd__mux2_1 A0 A1 S VGND VNB VPB VPWR X
.ends

* Black-box entry subcircuit for sky130_fd_sc_hd__xnor2_1 abstract view
.subckt sky130_fd_sc_hd__xnor2_1 A B VGND VNB VPB VPWR Y
.ends

* Black-box entry subcircuit for sky130_fd_sc_hd__dfrtp_1 abstract view
.subckt sky130_fd_sc_hd__dfrtp_1 CLK D RESET_B VGND VNB VPB VPWR Q
.ends

* Black-box entry subcircuit for sky130_fd_sc_hd__decap_8 abstract view
.subckt sky130_fd_sc_hd__decap_8 VGND VNB VPB VPWR
.ends

* Black-box entry subcircuit for sky130_fd_sc_hd__decap_3 abstract view
.subckt sky130_fd_sc_hd__decap_3 VGND VNB VPB VPWR
.ends

* Black-box entry subcircuit for sky130_fd_sc_hd__fill_1 abstract view
.subckt sky130_fd_sc_hd__fill_1 VGND VNB VPB VPWR
.ends

* Black-box entry subcircuit for sky130_fd_sc_hd__a21oi_1 abstract view
.subckt sky130_fd_sc_hd__a21oi_1 A1 A2 B1 VGND VNB VPB VPWR Y
.ends

* Black-box entry subcircuit for sky130_fd_sc_hd__a21o_1 abstract view
.subckt sky130_fd_sc_hd__a21o_1 A1 A2 B1 VGND VNB VPB VPWR X
.ends

* Black-box entry subcircuit for sky130_fd_sc_hd__nand3_1 abstract view
.subckt sky130_fd_sc_hd__nand3_1 A B C VGND VNB VPB VPWR Y
.ends

* Black-box entry subcircuit for sky130_fd_sc_hd__o21ai_1 abstract view
.subckt sky130_fd_sc_hd__o21ai_1 A1 A2 B1 VGND VNB VPB VPWR Y
.ends

* Black-box entry subcircuit for sky130_fd_sc_hd__a31o_1 abstract view
.subckt sky130_fd_sc_hd__a31o_1 A1 A2 A3 B1 VGND VNB VPB VPWR X
.ends

* Black-box entry subcircuit for sky130_fd_sc_hd__a311o_1 abstract view
.subckt sky130_fd_sc_hd__a311o_1 A1 A2 A3 B1 C1 VGND VNB VPB VPWR X
.ends

* Black-box entry subcircuit for sky130_fd_sc_hd__buf_2 abstract view
.subckt sky130_fd_sc_hd__buf_2 A VGND VNB VPB VPWR X
.ends

* Black-box entry subcircuit for sky130_fd_sc_hd__clkbuf_2 abstract view
.subckt sky130_fd_sc_hd__clkbuf_2 A VGND VNB VPB VPWR X
.ends

* Black-box entry subcircuit for sky130_fd_sc_hd__o32a_1 abstract view
.subckt sky130_fd_sc_hd__o32a_1 A1 A2 A3 B1 B2 VGND VNB VPB VPWR X
.ends

* Black-box entry subcircuit for sky130_fd_sc_hd__and4b_1 abstract view
.subckt sky130_fd_sc_hd__and4b_1 A_N B C D VGND VNB VPB VPWR X
.ends

* Black-box entry subcircuit for sky130_fd_sc_hd__nor2_1 abstract view
.subckt sky130_fd_sc_hd__nor2_1 A B VGND VNB VPB VPWR Y
.ends

* Black-box entry subcircuit for sky130_fd_sc_hd__inv_2 abstract view
.subckt sky130_fd_sc_hd__inv_2 A VGND VNB VPB VPWR Y
.ends

* Black-box entry subcircuit for sky130_fd_sc_hd__nand2b_1 abstract view
.subckt sky130_fd_sc_hd__nand2b_1 A_N B VGND VNB VPB VPWR Y
.ends

* Black-box entry subcircuit for sky130_fd_sc_hd__dlygate4sd3_1 abstract view
.subckt sky130_fd_sc_hd__dlygate4sd3_1 A VGND VNB VPB VPWR X
.ends

* Black-box entry subcircuit for sky130_fd_sc_hd__decap_6 abstract view
.subckt sky130_fd_sc_hd__decap_6 VGND VNB VPB VPWR
.ends

* Black-box entry subcircuit for sky130_fd_sc_hd__a211oi_1 abstract view
.subckt sky130_fd_sc_hd__a211oi_1 A1 A2 B1 C1 VGND VNB VPB VPWR Y
.ends

* Black-box entry subcircuit for sky130_fd_sc_hd__or2_1 abstract view
.subckt sky130_fd_sc_hd__or2_1 A B VGND VNB VPB VPWR X
.ends

* Black-box entry subcircuit for sky130_fd_sc_hd__and2_1 abstract view
.subckt sky130_fd_sc_hd__and2_1 A B VGND VNB VPB VPWR X
.ends

* Black-box entry subcircuit for sky130_fd_sc_hd__nand3b_1 abstract view
.subckt sky130_fd_sc_hd__nand3b_1 A_N B C VGND VNB VPB VPWR Y
.ends

* Black-box entry subcircuit for sky130_fd_sc_hd__dfrtp_4 abstract view
.subckt sky130_fd_sc_hd__dfrtp_4 CLK D RESET_B VGND VNB VPB VPWR Q
.ends

* Black-box entry subcircuit for sky130_fd_sc_hd__o211ai_1 abstract view
.subckt sky130_fd_sc_hd__o211ai_1 A1 A2 B1 C1 VGND VNB VPB VPWR Y
.ends

* Black-box entry subcircuit for sky130_fd_sc_hd__a22o_1 abstract view
.subckt sky130_fd_sc_hd__a22o_1 A1 A2 B1 B2 VGND VNB VPB VPWR X
.ends

* Black-box entry subcircuit for sky130_fd_sc_hd__o22a_1 abstract view
.subckt sky130_fd_sc_hd__o22a_1 A1 A2 B1 B2 VGND VNB VPB VPWR X
.ends

* Black-box entry subcircuit for sky130_fd_sc_hd__dfrtp_2 abstract view
.subckt sky130_fd_sc_hd__dfrtp_2 CLK D RESET_B VGND VNB VPB VPWR Q
.ends

* Black-box entry subcircuit for sky130_fd_sc_hd__o211a_1 abstract view
.subckt sky130_fd_sc_hd__o211a_1 A1 A2 B1 C1 VGND VNB VPB VPWR X
.ends

* Black-box entry subcircuit for sky130_fd_sc_hd__nand2_1 abstract view
.subckt sky130_fd_sc_hd__nand2_1 A B VGND VNB VPB VPWR Y
.ends

* Black-box entry subcircuit for sky130_fd_sc_hd__a31oi_2 abstract view
.subckt sky130_fd_sc_hd__a31oi_2 A1 A2 A3 B1 VGND VNB VPB VPWR Y
.ends

* Black-box entry subcircuit for sky130_fd_sc_hd__a22oi_1 abstract view
.subckt sky130_fd_sc_hd__a22oi_1 A1 A2 B1 B2 VGND VNB VPB VPWR Y
.ends

* Black-box entry subcircuit for sky130_fd_sc_hd__nand3_4 abstract view
.subckt sky130_fd_sc_hd__nand3_4 A B C VGND VNB VPB VPWR Y
.ends

* Black-box entry subcircuit for sky130_fd_sc_hd__or3b_1 abstract view
.subckt sky130_fd_sc_hd__or3b_1 A B C_N VGND VNB VPB VPWR X
.ends

* Black-box entry subcircuit for sky130_fd_sc_hd__o31a_1 abstract view
.subckt sky130_fd_sc_hd__o31a_1 A1 A2 A3 B1 VGND VNB VPB VPWR X
.ends

* Black-box entry subcircuit for sky130_fd_sc_hd__o2bb2ai_1 abstract view
.subckt sky130_fd_sc_hd__o2bb2ai_1 A1_N A2_N B1 B2 VGND VNB VPB VPWR Y
.ends

* Black-box entry subcircuit for sky130_fd_sc_hd__o21a_1 abstract view
.subckt sky130_fd_sc_hd__o21a_1 A1 A2 B1 VGND VNB VPB VPWR X
.ends

* Black-box entry subcircuit for sky130_fd_sc_hd__a32o_1 abstract view
.subckt sky130_fd_sc_hd__a32o_1 A1 A2 A3 B1 B2 VGND VNB VPB VPWR X
.ends

* Black-box entry subcircuit for sky130_fd_sc_hd__clkbuf_8 abstract view
.subckt sky130_fd_sc_hd__clkbuf_8 A VGND VNB VPB VPWR X
.ends

* Black-box entry subcircuit for sky130_fd_sc_hd__a211o_1 abstract view
.subckt sky130_fd_sc_hd__a211o_1 A1 A2 B1 C1 VGND VNB VPB VPWR X
.ends

* Black-box entry subcircuit for sky130_fd_sc_hd__o311ai_1 abstract view
.subckt sky130_fd_sc_hd__o311ai_1 A1 A2 A3 B1 C1 VGND VNB VPB VPWR Y
.ends

* Black-box entry subcircuit for sky130_fd_sc_hd__nor3_1 abstract view
.subckt sky130_fd_sc_hd__nor3_1 A B C VGND VNB VPB VPWR Y
.ends

* Black-box entry subcircuit for sky130_fd_sc_hd__a221oi_2 abstract view
.subckt sky130_fd_sc_hd__a221oi_2 A1 A2 B1 B2 C1 VGND VNB VPB VPWR Y
.ends

* Black-box entry subcircuit for sky130_fd_sc_hd__nand4_1 abstract view
.subckt sky130_fd_sc_hd__nand4_1 A B C D VGND VNB VPB VPWR Y
.ends

* Black-box entry subcircuit for sky130_fd_sc_hd__nand2_2 abstract view
.subckt sky130_fd_sc_hd__nand2_2 A B VGND VNB VPB VPWR Y
.ends

* Black-box entry subcircuit for sky130_fd_sc_hd__o21bai_1 abstract view
.subckt sky130_fd_sc_hd__o21bai_1 A1 A2 B1_N VGND VNB VPB VPWR Y
.ends

* Black-box entry subcircuit for sky130_fd_sc_hd__o21ba_1 abstract view
.subckt sky130_fd_sc_hd__o21ba_1 A1 A2 B1_N VGND VNB VPB VPWR X
.ends

* Black-box entry subcircuit for sky130_fd_sc_hd__o221a_1 abstract view
.subckt sky130_fd_sc_hd__o221a_1 A1 A2 B1 B2 C1 VGND VNB VPB VPWR X
.ends

* Black-box entry subcircuit for sky130_fd_sc_hd__o2bb2a_1 abstract view
.subckt sky130_fd_sc_hd__o2bb2a_1 A1_N A2_N B1 B2 VGND VNB VPB VPWR X
.ends

* Black-box entry subcircuit for sky130_fd_sc_hd__nand2b_4 abstract view
.subckt sky130_fd_sc_hd__nand2b_4 A_N B VGND VNB VPB VPWR Y
.ends

* Black-box entry subcircuit for sky130_fd_sc_hd__o41a_1 abstract view
.subckt sky130_fd_sc_hd__o41a_1 A1 A2 A3 A4 B1 VGND VNB VPB VPWR X
.ends

* Black-box entry subcircuit for sky130_fd_sc_hd__nor2_2 abstract view
.subckt sky130_fd_sc_hd__nor2_2 A B VGND VNB VPB VPWR Y
.ends

* Black-box entry subcircuit for sky130_fd_sc_hd__or3_1 abstract view
.subckt sky130_fd_sc_hd__or3_1 A B C VGND VNB VPB VPWR X
.ends

* Black-box entry subcircuit for sky130_fd_sc_hd__a21boi_1 abstract view
.subckt sky130_fd_sc_hd__a21boi_1 A1 A2 B1_N VGND VNB VPB VPWR Y
.ends

* Black-box entry subcircuit for sky130_fd_sc_hd__a22oi_2 abstract view
.subckt sky130_fd_sc_hd__a22oi_2 A1 A2 B1 B2 VGND VNB VPB VPWR Y
.ends

* Black-box entry subcircuit for sky130_fd_sc_hd__nor3b_1 abstract view
.subckt sky130_fd_sc_hd__nor3b_1 A B C_N VGND VNB VPB VPWR Y
.ends

* Black-box entry subcircuit for sky130_fd_sc_hd__a2bb2o_1 abstract view
.subckt sky130_fd_sc_hd__a2bb2o_1 A1_N A2_N B1 B2 VGND VNB VPB VPWR X
.ends

* Black-box entry subcircuit for sky130_fd_sc_hd__and4bb_1 abstract view
.subckt sky130_fd_sc_hd__and4bb_1 A_N B_N C D VGND VNB VPB VPWR X
.ends

* Black-box entry subcircuit for sky130_fd_sc_hd__o211ai_2 abstract view
.subckt sky130_fd_sc_hd__o211ai_2 A1 A2 B1 C1 VGND VNB VPB VPWR Y
.ends

* Black-box entry subcircuit for sky130_fd_sc_hd__a21boi_2 abstract view
.subckt sky130_fd_sc_hd__a21boi_2 A1 A2 B1_N VGND VNB VPB VPWR Y
.ends

* Black-box entry subcircuit for sky130_fd_sc_hd__nand2_4 abstract view
.subckt sky130_fd_sc_hd__nand2_4 A B VGND VNB VPB VPWR Y
.ends

* Black-box entry subcircuit for sky130_fd_sc_hd__inv_6 abstract view
.subckt sky130_fd_sc_hd__inv_6 A VGND VNB VPB VPWR Y
.ends

* Black-box entry subcircuit for sky130_fd_sc_hd__nand4_2 abstract view
.subckt sky130_fd_sc_hd__nand4_2 A B C D VGND VNB VPB VPWR Y
.ends

* Black-box entry subcircuit for sky130_fd_sc_hd__o21bai_2 abstract view
.subckt sky130_fd_sc_hd__o21bai_2 A1 A2 B1_N VGND VNB VPB VPWR Y
.ends

* Black-box entry subcircuit for sky130_fd_sc_hd__and3b_1 abstract view
.subckt sky130_fd_sc_hd__and3b_1 A_N B C VGND VNB VPB VPWR X
.ends

* Black-box entry subcircuit for sky130_fd_sc_hd__o211a_2 abstract view
.subckt sky130_fd_sc_hd__o211a_2 A1 A2 B1 C1 VGND VNB VPB VPWR X
.ends

* Black-box entry subcircuit for sky130_fd_sc_hd__o21ai_2 abstract view
.subckt sky130_fd_sc_hd__o21ai_2 A1 A2 B1 VGND VNB VPB VPWR Y
.ends

* Black-box entry subcircuit for sky130_fd_sc_hd__o21ai_4 abstract view
.subckt sky130_fd_sc_hd__o21ai_4 A1 A2 B1 VGND VNB VPB VPWR Y
.ends

* Black-box entry subcircuit for sky130_fd_sc_hd__nor3_2 abstract view
.subckt sky130_fd_sc_hd__nor3_2 A B C VGND VNB VPB VPWR Y
.ends

* Black-box entry subcircuit for sky130_fd_sc_hd__and2b_1 abstract view
.subckt sky130_fd_sc_hd__and2b_1 A_N B VGND VNB VPB VPWR X
.ends

* Black-box entry subcircuit for sky130_fd_sc_hd__clkbuf_4 abstract view
.subckt sky130_fd_sc_hd__clkbuf_4 A VGND VNB VPB VPWR X
.ends

* Black-box entry subcircuit for sky130_fd_sc_hd__o21bai_4 abstract view
.subckt sky130_fd_sc_hd__o21bai_4 A1 A2 B1_N VGND VNB VPB VPWR Y
.ends

* Black-box entry subcircuit for sky130_fd_sc_hd__o311a_1 abstract view
.subckt sky130_fd_sc_hd__o311a_1 A1 A2 A3 B1 C1 VGND VNB VPB VPWR X
.ends

* Black-box entry subcircuit for sky130_fd_sc_hd__nand3b_2 abstract view
.subckt sky130_fd_sc_hd__nand3b_2 A_N B C VGND VNB VPB VPWR Y
.ends

* Black-box entry subcircuit for sky130_fd_sc_hd__buf_1 abstract view
.subckt sky130_fd_sc_hd__buf_1 A VGND VNB VPB VPWR X
.ends

* Black-box entry subcircuit for sky130_fd_sc_hd__and4_1 abstract view
.subckt sky130_fd_sc_hd__and4_1 A B C D VGND VNB VPB VPWR X
.ends

* Black-box entry subcircuit for sky130_fd_sc_hd__a31o_2 abstract view
.subckt sky130_fd_sc_hd__a31o_2 A1 A2 A3 B1 VGND VNB VPB VPWR X
.ends

* Black-box entry subcircuit for sky130_fd_sc_hd__nand3_2 abstract view
.subckt sky130_fd_sc_hd__nand3_2 A B C VGND VNB VPB VPWR Y
.ends

* Black-box entry subcircuit for sky130_fd_sc_hd__a21oi_2 abstract view
.subckt sky130_fd_sc_hd__a21oi_2 A1 A2 B1 VGND VNB VPB VPWR Y
.ends

* Black-box entry subcircuit for sky130_fd_sc_hd__clkinvlp_4 abstract view
.subckt sky130_fd_sc_hd__clkinvlp_4 A VGND VNB VPB VPWR Y
.ends

* Black-box entry subcircuit for sky130_fd_sc_hd__o22ai_1 abstract view
.subckt sky130_fd_sc_hd__o22ai_1 A1 A2 B1 B2 VGND VNB VPB VPWR Y
.ends

* Black-box entry subcircuit for sky130_fd_sc_hd__clkinv_2 abstract view
.subckt sky130_fd_sc_hd__clkinv_2 A VGND VNB VPB VPWR Y
.ends

* Black-box entry subcircuit for sky130_fd_sc_hd__inv_8 abstract view
.subckt sky130_fd_sc_hd__inv_8 A VGND VNB VPB VPWR Y
.ends

* Black-box entry subcircuit for sky130_fd_sc_hd__a2bb2oi_1 abstract view
.subckt sky130_fd_sc_hd__a2bb2oi_1 A1_N A2_N B1 B2 VGND VNB VPB VPWR Y
.ends

* Black-box entry subcircuit for sky130_fd_sc_hd__clkbuf_16 abstract view
.subckt sky130_fd_sc_hd__clkbuf_16 A VGND VNB VPB VPWR X
.ends

* Black-box entry subcircuit for sky130_fd_sc_hd__xor2_2 abstract view
.subckt sky130_fd_sc_hd__xor2_2 A B VGND VNB VPB VPWR X
.ends

* Black-box entry subcircuit for sky130_fd_sc_hd__clkinv_8 abstract view
.subckt sky130_fd_sc_hd__clkinv_8 A VGND VNB VPB VPWR Y
.ends

* Black-box entry subcircuit for sky130_fd_sc_hd__inv_4 abstract view
.subckt sky130_fd_sc_hd__inv_4 A VGND VNB VPB VPWR Y
.ends

* Black-box entry subcircuit for sky130_fd_sc_hd__dlymetal6s2s_1 abstract view
.subckt sky130_fd_sc_hd__dlymetal6s2s_1 A VGND VNB VPB VPWR X
.ends

* Black-box entry subcircuit for sky130_fd_sc_hd__nor4_1 abstract view
.subckt sky130_fd_sc_hd__nor4_1 A B C D VGND VNB VPB VPWR Y
.ends

* Black-box entry subcircuit for sky130_fd_sc_hd__bufinv_16 abstract view
.subckt sky130_fd_sc_hd__bufinv_16 A VGND VNB VPB VPWR Y
.ends

* Black-box entry subcircuit for sky130_fd_sc_hd__or2_2 abstract view
.subckt sky130_fd_sc_hd__or2_2 A B VGND VNB VPB VPWR X
.ends

* Black-box entry subcircuit for sky130_fd_sc_hd__o221ai_4 abstract view
.subckt sky130_fd_sc_hd__o221ai_4 A1 A2 B1 B2 C1 VGND VNB VPB VPWR Y
.ends

* Black-box entry subcircuit for sky130_fd_sc_hd__a311oi_1 abstract view
.subckt sky130_fd_sc_hd__a311oi_1 A1 A2 A3 B1 C1 VGND VNB VPB VPWR Y
.ends

* Black-box entry subcircuit for sky130_fd_sc_hd__a32oi_1 abstract view
.subckt sky130_fd_sc_hd__a32oi_1 A1 A2 A3 B1 B2 VGND VNB VPB VPWR Y
.ends

* Black-box entry subcircuit for sky130_fd_sc_hd__or3_2 abstract view
.subckt sky130_fd_sc_hd__or3_2 A B C VGND VNB VPB VPWR X
.ends

* Black-box entry subcircuit for sky130_fd_sc_hd__clkinv_4 abstract view
.subckt sky130_fd_sc_hd__clkinv_4 A VGND VNB VPB VPWR Y
.ends

* Black-box entry subcircuit for sky130_fd_sc_hd__a21bo_1 abstract view
.subckt sky130_fd_sc_hd__a21bo_1 A1 A2 B1_N VGND VNB VPB VPWR X
.ends

* Black-box entry subcircuit for sky130_fd_sc_hd__a221o_1 abstract view
.subckt sky130_fd_sc_hd__a221o_1 A1 A2 B1 B2 C1 VGND VNB VPB VPWR X
.ends

* Black-box entry subcircuit for sky130_fd_sc_hd__o221ai_1 abstract view
.subckt sky130_fd_sc_hd__o221ai_1 A1 A2 B1 B2 C1 VGND VNB VPB VPWR Y
.ends

* Black-box entry subcircuit for sky130_fd_sc_hd__and2_2 abstract view
.subckt sky130_fd_sc_hd__and2_2 A B VGND VNB VPB VPWR X
.ends

* Black-box entry subcircuit for sky130_fd_sc_hd__or4_1 abstract view
.subckt sky130_fd_sc_hd__or4_1 A B C D VGND VNB VPB VPWR X
.ends

* Black-box entry subcircuit for sky130_fd_sc_hd__a211oi_2 abstract view
.subckt sky130_fd_sc_hd__a211oi_2 A1 A2 B1 C1 VGND VNB VPB VPWR Y
.ends

* Black-box entry subcircuit for sky130_fd_sc_hd__clkbuf_1 abstract view
.subckt sky130_fd_sc_hd__clkbuf_1 A VGND VNB VPB VPWR X
.ends

* Black-box entry subcircuit for sky130_fd_sc_hd__a22oi_4 abstract view
.subckt sky130_fd_sc_hd__a22oi_4 A1 A2 B1 B2 VGND VNB VPB VPWR Y
.ends

* Black-box entry subcircuit for sky130_fd_sc_hd__a31oi_1 abstract view
.subckt sky130_fd_sc_hd__a31oi_1 A1 A2 A3 B1 VGND VNB VPB VPWR Y
.ends

* Black-box entry subcircuit for sky130_fd_sc_hd__a311oi_4 abstract view
.subckt sky130_fd_sc_hd__a311oi_4 A1 A2 A3 B1 C1 VGND VNB VPB VPWR Y
.ends

* Black-box entry subcircuit for sky130_fd_sc_hd__o41ai_2 abstract view
.subckt sky130_fd_sc_hd__o41ai_2 A1 A2 A3 A4 B1 VGND VNB VPB VPWR Y
.ends

* Black-box entry subcircuit for sky130_fd_sc_hd__a41oi_4 abstract view
.subckt sky130_fd_sc_hd__a41oi_4 A1 A2 A3 A4 B1 VGND VNB VPB VPWR Y
.ends

* Black-box entry subcircuit for sky130_fd_sc_hd__o221ai_2 abstract view
.subckt sky130_fd_sc_hd__o221ai_2 A1 A2 B1 B2 C1 VGND VNB VPB VPWR Y
.ends

* Black-box entry subcircuit for sky130_fd_sc_hd__o31ai_2 abstract view
.subckt sky130_fd_sc_hd__o31ai_2 A1 A2 A3 B1 VGND VNB VPB VPWR Y
.ends

* Black-box entry subcircuit for sky130_fd_sc_hd__o22ai_2 abstract view
.subckt sky130_fd_sc_hd__o22ai_2 A1 A2 B1 B2 VGND VNB VPB VPWR Y
.ends

* Black-box entry subcircuit for sky130_fd_sc_hd__a2111oi_2 abstract view
.subckt sky130_fd_sc_hd__a2111oi_2 A1 A2 B1 C1 D1 VGND VNB VPB VPWR Y
.ends

* Black-box entry subcircuit for sky130_fd_sc_hd__buf_4 abstract view
.subckt sky130_fd_sc_hd__buf_4 A VGND VNB VPB VPWR X
.ends

* Black-box entry subcircuit for sky130_fd_sc_hd__or3b_2 abstract view
.subckt sky130_fd_sc_hd__or3b_2 A B C_N VGND VNB VPB VPWR X
.ends

* Black-box entry subcircuit for sky130_fd_sc_hd__or4b_1 abstract view
.subckt sky130_fd_sc_hd__or4b_1 A B C D_N VGND VNB VPB VPWR X
.ends

* Black-box entry subcircuit for sky130_fd_sc_hd__o2111ai_1 abstract view
.subckt sky130_fd_sc_hd__o2111ai_1 A1 A2 B1 C1 D1 VGND VNB VPB VPWR Y
.ends

* Black-box entry subcircuit for sky130_fd_sc_hd__o211ai_4 abstract view
.subckt sky130_fd_sc_hd__o211ai_4 A1 A2 B1 C1 VGND VNB VPB VPWR Y
.ends

* Black-box entry subcircuit for sky130_fd_sc_hd__nand4b_1 abstract view
.subckt sky130_fd_sc_hd__nand4b_1 A_N B C D VGND VNB VPB VPWR Y
.ends

* Black-box entry subcircuit for sky130_fd_sc_hd__a32oi_4 abstract view
.subckt sky130_fd_sc_hd__a32oi_4 A1 A2 A3 B1 B2 VGND VNB VPB VPWR Y
.ends

* Black-box entry subcircuit for sky130_fd_sc_hd__a211oi_4 abstract view
.subckt sky130_fd_sc_hd__a211oi_4 A1 A2 B1 C1 VGND VNB VPB VPWR Y
.ends

* Black-box entry subcircuit for sky130_fd_sc_hd__o2111a_1 abstract view
.subckt sky130_fd_sc_hd__o2111a_1 A1 A2 B1 C1 D1 VGND VNB VPB VPWR X
.ends

* Black-box entry subcircuit for sky130_fd_sc_hd__xnor2_2 abstract view
.subckt sky130_fd_sc_hd__xnor2_2 A B VGND VNB VPB VPWR Y
.ends

* Black-box entry subcircuit for sky130_fd_sc_hd__o31ai_1 abstract view
.subckt sky130_fd_sc_hd__o31ai_1 A1 A2 A3 B1 VGND VNB VPB VPWR Y
.ends

* Black-box entry subcircuit for sky130_fd_sc_hd__o221a_2 abstract view
.subckt sky130_fd_sc_hd__o221a_2 A1 A2 B1 B2 C1 VGND VNB VPB VPWR X
.ends

* Black-box entry subcircuit for sky130_fd_sc_hd__or4bb_1 abstract view
.subckt sky130_fd_sc_hd__or4bb_1 A B C_N D_N VGND VNB VPB VPWR X
.ends

* Black-box entry subcircuit for sky130_fd_sc_hd__a31oi_4 abstract view
.subckt sky130_fd_sc_hd__a31oi_4 A1 A2 A3 B1 VGND VNB VPB VPWR Y
.ends

* Black-box entry subcircuit for sky130_fd_sc_hd__xor2_4 abstract view
.subckt sky130_fd_sc_hd__xor2_4 A B VGND VNB VPB VPWR X
.ends

* Black-box entry subcircuit for sky130_fd_sc_hd__a41oi_2 abstract view
.subckt sky130_fd_sc_hd__a41oi_2 A1 A2 A3 A4 B1 VGND VNB VPB VPWR Y
.ends

* Black-box entry subcircuit for sky130_fd_sc_hd__a2111oi_1 abstract view
.subckt sky130_fd_sc_hd__a2111oi_1 A1 A2 B1 C1 D1 VGND VNB VPB VPWR Y
.ends

* Black-box entry subcircuit for sky130_fd_sc_hd__nand3b_4 abstract view
.subckt sky130_fd_sc_hd__nand3b_4 A_N B C VGND VNB VPB VPWR Y
.ends

* Black-box entry subcircuit for sky130_fd_sc_hd__o41ai_4 abstract view
.subckt sky130_fd_sc_hd__o41ai_4 A1 A2 A3 A4 B1 VGND VNB VPB VPWR Y
.ends

* Black-box entry subcircuit for sky130_fd_sc_hd__o41ai_1 abstract view
.subckt sky130_fd_sc_hd__o41ai_1 A1 A2 A3 A4 B1 VGND VNB VPB VPWR Y
.ends

.subckt mac_engine_2 clk m_axis_tdata[0] m_axis_tdata[10] m_axis_tdata[11] m_axis_tdata[12]
+ m_axis_tdata[13] m_axis_tdata[14] m_axis_tdata[15] m_axis_tdata[16] m_axis_tdata[17]
+ m_axis_tdata[18] m_axis_tdata[19] m_axis_tdata[1] m_axis_tdata[20] m_axis_tdata[21]
+ m_axis_tdata[22] m_axis_tdata[23] m_axis_tdata[24] m_axis_tdata[25] m_axis_tdata[26]
+ m_axis_tdata[27] m_axis_tdata[28] m_axis_tdata[29] m_axis_tdata[2] m_axis_tdata[30]
+ m_axis_tdata[31] m_axis_tdata[32] m_axis_tdata[33] m_axis_tdata[34] m_axis_tdata[35]
+ m_axis_tdata[36] m_axis_tdata[37] m_axis_tdata[38] m_axis_tdata[39] m_axis_tdata[3]
+ m_axis_tdata[4] m_axis_tdata[5] m_axis_tdata[6] m_axis_tdata[7] m_axis_tdata[8]
+ m_axis_tdata[9] m_axis_tready m_axis_tvalid rst_n s_axis_tdata[0] s_axis_tdata[10]
+ s_axis_tdata[11] s_axis_tdata[12] s_axis_tdata[13] s_axis_tdata[14] s_axis_tdata[15]
+ s_axis_tdata[16] s_axis_tdata[17] s_axis_tdata[18] s_axis_tdata[19] s_axis_tdata[1]
+ s_axis_tdata[20] s_axis_tdata[21] s_axis_tdata[22] s_axis_tdata[23] s_axis_tdata[24]
+ s_axis_tdata[25] s_axis_tdata[26] s_axis_tdata[27] s_axis_tdata[28] s_axis_tdata[29]
+ s_axis_tdata[2] s_axis_tdata[30] s_axis_tdata[31] s_axis_tdata[3] s_axis_tdata[4]
+ s_axis_tdata[5] s_axis_tdata[6] s_axis_tdata[7] s_axis_tdata[8] s_axis_tdata[9]
+ s_axis_tready s_axis_tuser s_axis_tvalid vccd1 vssd1
XFILLER_39_211 vssd1 vssd1 vccd1 vccd1 sky130_fd_sc_hd__decap_4
X_3155_ _3155_/A _3155_/B vssd1 vssd1 vccd1 vccd1 _3155_/X sky130_fd_sc_hd__xor2_1
XFILLER_82_501 vccd1 vssd1 vccd1 vssd1 sky130_ef_sc_hd__decap_12
X_3086_ _3087_/A _3087_/B _3087_/C vssd1 vssd1 vccd1 vccd1 _3086_/X sky130_fd_sc_hd__and3_1
XFILLER_27_428 vccd1 vssd1 vccd1 vssd1 sky130_ef_sc_hd__decap_12
XFILLER_42_409 vssd1 vssd1 vccd1 vccd1 sky130_fd_sc_hd__fill_2
XFILLER_54_247 vssd1 vssd1 vccd1 vccd1 sky130_fd_sc_hd__decap_4
XTAP_TAPCELL_ROW_65_776 vssd1 vccd1 sky130_fd_sc_hd__tapvpwrvgnd_1
XANTENNA__4092__D _4227_/C vssd1 vssd1 vccd1 vccd1 sky130_fd_sc_hd__diode_2
X_3988_ _4020_/A0 _4020_/A1 _4123_/S vssd1 vssd1 vccd1 vccd1 _3988_/X sky130_fd_sc_hd__mux2_1
XANTENNA_fanout427_A fanout440/X vssd1 vssd1 vccd1 vccd1 sky130_fd_sc_hd__diode_2
X_2939_ _4734_/Q _2939_/B vssd1 vssd1 vccd1 vccd1 _2940_/C sky130_fd_sc_hd__xnor2_1
XTAP_TAPCELL_ROW_20_367 vssd1 vccd1 sky130_fd_sc_hd__tapvpwrvgnd_1
X_4609_ _4609_/CLK _4609_/D fanout429/X vssd1 vssd1 vccd1 vccd1 _4609_/Q sky130_fd_sc_hd__dfrtp_1
XFILLER_85_361 vssd1 vssd1 vccd1 vccd1 sky130_fd_sc_hd__decap_8
XFILLER_18_417 vssd1 vssd1 vccd1 vccd1 sky130_fd_sc_hd__decap_3
XTAP_TAPCELL_ROW_28_445 vssd1 vccd1 sky130_fd_sc_hd__tapvpwrvgnd_1
XFILLER_45_247 vccd1 vssd1 vccd1 vssd1 sky130_ef_sc_hd__decap_12
XFILLER_26_63 vccd1 vssd1 vccd1 vssd1 sky130_ef_sc_hd__decap_12
XANTENNA__3434__A2 _3504_/A2 vssd1 vssd1 vccd1 vccd1 sky130_fd_sc_hd__diode_2
XFILLER_42_73 vssd1 vssd1 vccd1 vccd1 sky130_fd_sc_hd__fill_1
XANTENNA__4147__A0 _4171_/A0 vssd1 vssd1 vccd1 vccd1 sky130_fd_sc_hd__diode_2
XFILLER_36_203 vssd1 vssd1 vccd1 vccd1 sky130_fd_sc_hd__fill_1
XANTENNA__3425__A2 _3425_/A2 vssd1 vssd1 vccd1 vccd1 sky130_fd_sc_hd__diode_2
XFILLER_51_206 vccd1 vssd1 vccd1 vssd1 sky130_ef_sc_hd__decap_12
XFILLER_51_228 vssd1 vssd1 vccd1 vccd1 sky130_fd_sc_hd__decap_4
XTAP_TAPCELL_ROW_62_746 vssd1 vccd1 sky130_fd_sc_hd__tapvpwrvgnd_1
X_3911_ _3946_/A2 _3946_/A1 hold111/X vssd1 vssd1 vccd1 vccd1 _3911_/Y sky130_fd_sc_hd__a21oi_1
X_3842_ hold207/X _3848_/A2 _3841_/Y vssd1 vssd1 vccd1 vccd1 _4639_/D sky130_fd_sc_hd__a21o_1
XANTENNA__4386__A0 _4071_/S vssd1 vssd1 vccd1 vccd1 sky130_fd_sc_hd__diode_2
X_3773_ _4536_/Q _4645_/Q vssd1 vssd1 vccd1 vccd1 _3774_/B sky130_fd_sc_hd__xnor2_1
X_2724_ _2724_/A _2724_/B _2724_/C vssd1 vssd1 vccd1 vccd1 _2725_/B sky130_fd_sc_hd__nand3_1
X_2655_ _2641_/A _2641_/B _2654_/Y vssd1 vssd1 vccd1 vccd1 _2655_/Y sky130_fd_sc_hd__o21ai_1
X_2586_ _2552_/B _2542_/B _2588_/B _2551_/A vssd1 vssd1 vccd1 vccd1 _2592_/A sky130_fd_sc_hd__a31o_1
X_4325_ _4253_/S _4328_/C _4328_/B _4376_/A2 _4324_/Y vssd1 vssd1 vccd1 vccd1 _4325_/X
+ sky130_fd_sc_hd__a311o_1
Xfanout127 _4314_/S vssd1 vssd1 vccd1 vccd1 _4361_/B1 sky130_fd_sc_hd__buf_2
Xfanout105 _3534_/A2 vssd1 vssd1 vccd1 vccd1 _3522_/A2 sky130_fd_sc_hd__buf_2
Xfanout116 _2797_/A2 vssd1 vssd1 vccd1 vccd1 _3870_/B1 sky130_fd_sc_hd__buf_2
Xfanout138 fanout141/X vssd1 vssd1 vccd1 vccd1 _4130_/B1 sky130_fd_sc_hd__clkbuf_2
X_4256_ _4255_/Y _4254_/X _4253_/X hold165/X _4264_/B2 vssd1 vssd1 vccd1 vccd1 _4756_/D
+ sky130_fd_sc_hd__o32a_1
Xfanout149 _4225_/B2 vssd1 vssd1 vccd1 vccd1 _4224_/B1 sky130_fd_sc_hd__clkbuf_2
XANTENNA__4310__B1 _4361_/B1 vssd1 vssd1 vccd1 vccd1 sky130_fd_sc_hd__diode_2
X_4187_ _4258_/C _4211_/B _4199_/D _4789_/Q vssd1 vssd1 vccd1 vccd1 _4187_/X sky130_fd_sc_hd__and4b_1
X_3207_ _3207_/A _3207_/B vssd1 vssd1 vccd1 vccd1 _3432_/A sky130_fd_sc_hd__nor2_1
X_3138_ _3138_/A vssd1 vssd1 vccd1 vccd1 _3138_/Y sky130_fd_sc_hd__inv_2
XTAP_TAPCELL_ROW_78_890 vssd1 vccd1 sky130_fd_sc_hd__tapvpwrvgnd_1
XANTENNA_fanout377_A fanout379/X vssd1 vssd1 vccd1 vccd1 sky130_fd_sc_hd__diode_2
X_3069_ _3067_/Y _3069_/B vssd1 vssd1 vccd1 vccd1 _3069_/Y sky130_fd_sc_hd__nand2b_1
XTAP_TAPCELL_ROW_25_415 vssd1 vccd1 sky130_fd_sc_hd__tapvpwrvgnd_1
XANTENNA__2624__B1 _3870_/B1 vssd1 vssd1 vccd1 vccd1 sky130_fd_sc_hd__diode_2
XANTENNA_fanout332_X _4266_/D vssd1 vssd1 vccd1 vccd1 sky130_fd_sc_hd__diode_2
XANTENNA__4377__B1 _4377_/B1 vssd1 vssd1 vccd1 vccd1 sky130_fd_sc_hd__diode_2
XFILLER_10_169 vssd1 vssd1 vccd1 vccd1 sky130_fd_sc_hd__fill_1
Xhold170 _4703_/Q vssd1 vssd1 vccd1 vccd1 hold170/X sky130_fd_sc_hd__dlygate4sd3_1
Xhold192 _4777_/Q vssd1 vssd1 vccd1 vccd1 hold192/X sky130_fd_sc_hd__dlygate4sd3_1
Xhold181 _4680_/Q vssd1 vssd1 vccd1 vccd1 hold181/X sky130_fd_sc_hd__dlygate4sd3_1
XFILLER_77_147 vssd1 vssd1 vccd1 vccd1 sky130_fd_sc_hd__decap_6
XFILLER_77_136 vssd1 vssd1 vccd1 vccd1 sky130_fd_sc_hd__decap_3
XANTENNA_clkbuf_leaf_31_clk_A clkbuf_2_3__f_clk/X vssd1 vssd1 vccd1 vccd1 sky130_fd_sc_hd__diode_2
XFILLER_77_169 vssd1 vssd1 vccd1 vccd1 sky130_fd_sc_hd__fill_1
XANTENNA_clkbuf_leaf_46_clk_A clkload0/A vssd1 vssd1 vccd1 vccd1 sky130_fd_sc_hd__diode_2
XFILLER_33_239 vccd1 vssd1 vccd1 vssd1 sky130_ef_sc_hd__decap_12
XFILLER_14_475 vssd1 vssd1 vccd1 vccd1 sky130_fd_sc_hd__fill_1
XANTENNA__4811__Q _4811_/Q vssd1 vssd1 vccd1 vccd1 sky130_fd_sc_hd__diode_2
X_2440_ _2435_/Y _2439_/Y _3806_/A2 vssd1 vssd1 vccd1 vccd1 _2440_/Y sky130_fd_sc_hd__o21ai_1
XFILLER_5_184 vssd1 vssd1 vccd1 vccd1 sky130_fd_sc_hd__decap_3
X_2371_ _4553_/Q hold51/A _2381_/S vssd1 vssd1 vccd1 vccd1 _2371_/X sky130_fd_sc_hd__mux2_1
XFILLER_78_91 vssd1 vssd1 vccd1 vccd1 sky130_fd_sc_hd__fill_1
X_4110_ _4136_/B _4116_/D _4116_/B _3884_/Y vssd1 vssd1 vccd1 vccd1 _4110_/Y sky130_fd_sc_hd__a211oi_1
X_4041_ _4036_/S _3976_/D _3975_/S vssd1 vssd1 vccd1 vccd1 _4041_/Y sky130_fd_sc_hd__a21oi_1
XFILLER_56_309 vssd1 vssd1 vccd1 vccd1 sky130_fd_sc_hd__fill_2
XFILLER_83_117 vssd1 vssd1 vccd1 vccd1 sky130_fd_sc_hd__decap_3
XTAP_TAPCELL_ROW_75_860 vssd1 vccd1 sky130_fd_sc_hd__tapvpwrvgnd_1
XFILLER_24_206 vssd1 vssd1 vccd1 vccd1 sky130_fd_sc_hd__decap_4
X_3825_ _3825_/A _3825_/B vssd1 vssd1 vccd1 vccd1 _3825_/X sky130_fd_sc_hd__or2_1
X_3756_ _3759_/C _3756_/B vssd1 vssd1 vccd1 vccd1 _3756_/Y sky130_fd_sc_hd__nor2_1
XANTENNA_fanout125_A _3890_/S vssd1 vssd1 vccd1 vccd1 sky130_fd_sc_hd__diode_2
XTAP_TAPCELL_ROW_30_462 vssd1 vccd1 sky130_fd_sc_hd__tapvpwrvgnd_1
X_2707_ _4742_/Q hold99/A vssd1 vssd1 vccd1 vccd1 _2709_/A sky130_fd_sc_hd__and2_1
X_3687_ _4526_/Q _4635_/Q _3686_/X vssd1 vssd1 vccd1 vccd1 _3687_/Y sky130_fd_sc_hd__a21oi_1
X_2638_ _2637_/Y _2638_/B _2688_/A vssd1 vssd1 vccd1 vccd1 _2688_/B sky130_fd_sc_hd__nand3b_1
X_2569_ _4738_/Q _4708_/Q vssd1 vssd1 vccd1 vccd1 _2571_/B sky130_fd_sc_hd__nor2_1
XFILLER_87_434 vccd1 vssd1 vccd1 vssd1 sky130_ef_sc_hd__decap_12
X_4308_ _4307_/Y _4306_/X _4305_/X _4769_/Q _4378_/B2 vssd1 vssd1 vccd1 vccd1 _4769_/D
+ sky130_fd_sc_hd__o32a_1
X_4239_ _4178_/D _4239_/B _4371_/A _4239_/D vssd1 vssd1 vccd1 vccd1 _4239_/X sky130_fd_sc_hd__and4b_1
XANTENNA_fanout282_X _4104_/B vssd1 vssd1 vccd1 vccd1 sky130_fd_sc_hd__diode_2
XFILLER_59_169 vssd1 vssd1 vccd1 vccd1 sky130_fd_sc_hd__fill_2
XFILLER_70_301 vssd1 vssd1 vccd1 vccd1 sky130_fd_sc_hd__decap_6
XFILLER_55_353 vssd1 vssd1 vccd1 vccd1 sky130_fd_sc_hd__fill_1
XFILLER_70_378 vccd1 vssd1 vccd1 vssd1 sky130_ef_sc_hd__decap_12
XFILLER_23_250 vssd1 vssd1 vccd1 vccd1 sky130_fd_sc_hd__fill_2
XFILLER_11_478 vccd1 vssd1 vccd1 vssd1 sky130_ef_sc_hd__decap_12
XFILLER_7_449 vccd1 vssd1 vccd1 vssd1 sky130_ef_sc_hd__decap_12
XFILLER_7_438 vssd1 vssd1 vccd1 vccd1 sky130_fd_sc_hd__decap_8
XTAP_TAPCELL_ROW_72_841 vssd1 vccd1 sky130_fd_sc_hd__tapvpwrvgnd_1
XFILLER_64_71 vssd1 vssd1 vccd1 vccd1 sky130_fd_sc_hd__decap_8
XFILLER_61_312 vccd1 vssd1 vccd1 vssd1 sky130_ef_sc_hd__decap_12
XANTENNA__4053__A2 _4081_/A2 vssd1 vssd1 vccd1 vccd1 sky130_fd_sc_hd__diode_2
XTAP_TAPCELL_ROW_44_587 vssd1 vccd1 sky130_fd_sc_hd__tapvpwrvgnd_1
X_4590_ _4624_/CLK _4590_/D fanout409/X vssd1 vssd1 vccd1 vccd1 _4590_/Q sky130_fd_sc_hd__dfrtp_4
X_3610_ _3604_/X _3605_/Y _3607_/Y _3609_/Y vssd1 vssd1 vccd1 vccd1 _3610_/Y sky130_fd_sc_hd__o211ai_1
X_3541_ _4581_/Q _2369_/S _3541_/B1 vssd1 vssd1 vccd1 vccd1 _4581_/D sky130_fd_sc_hd__a21o_1
XANTENNA__4199__B _4211_/B vssd1 vssd1 vccd1 vccd1 sky130_fd_sc_hd__diode_2
X_3472_ hold221/X _3540_/B2 _3470_/X _3471_/X vssd1 vssd1 vccd1 vccd1 _4566_/D sky130_fd_sc_hd__a22o_1
X_2423_ _4579_/Q hold75/A _2425_/S vssd1 vssd1 vccd1 vccd1 _2423_/X sky130_fd_sc_hd__mux2_1
X_2354_ hold21/X _2353_/X _2366_/S vssd1 vssd1 vccd1 vccd1 _4472_/D sky130_fd_sc_hd__mux2_1
XFILLER_69_478 vssd1 vssd1 vccd1 vccd1 sky130_fd_sc_hd__fill_1
X_2285_ hold107/X _3983_/B2 _2283_/Y _2284_/X vssd1 vssd1 vccd1 vccd1 _4453_/D sky130_fd_sc_hd__o22a_1
X_4024_ _4036_/A0 _4036_/A1 _4029_/D vssd1 vssd1 vccd1 vccd1 _4024_/X sky130_fd_sc_hd__mux2_1
XFILLER_20_220 vssd1 vssd1 vccd1 vccd1 sky130_fd_sc_hd__fill_1
X_3808_ _4622_/Q _3828_/A2 _2475_/X _3807_/Y vssd1 vssd1 vccd1 vccd1 _4622_/D sky130_fd_sc_hd__a22o_1
XFILLER_20_253 vccd1 vssd1 vccd1 vssd1 sky130_ef_sc_hd__decap_12
X_4788_ _4794_/CLK _4788_/D fanout375/X vssd1 vssd1 vccd1 vccd1 _4788_/Q sky130_fd_sc_hd__dfrtp_1
XANTENNA_fanout128_X _4314_/S vssd1 vssd1 vccd1 vccd1 sky130_fd_sc_hd__diode_2
X_3739_ _3743_/C _3743_/D vssd1 vssd1 vccd1 vccd1 _3740_/B sky130_fd_sc_hd__nor2_1
XFILLER_4_419 vssd1 vssd1 vccd1 vccd1 sky130_fd_sc_hd__fill_1
XANTENNA__2402__S _2420_/S vssd1 vssd1 vccd1 vccd1 sky130_fd_sc_hd__diode_2
XFILLER_87_253 vccd1 vssd1 vccd1 vssd1 sky130_ef_sc_hd__decap_12
XFILLER_85_15 vccd1 vssd1 vccd1 vssd1 sky130_ef_sc_hd__decap_12
XANTENNA_input2_X input2/X vssd1 vssd1 vccd1 vccd1 sky130_fd_sc_hd__diode_2
XTAP_TAPCELL_ROW_86_966 vssd1 vccd1 sky130_fd_sc_hd__tapvpwrvgnd_1
XFILLER_28_331 vccd1 vssd1 vccd1 vssd1 sky130_ef_sc_hd__decap_12
XANTENNA__2294__A1 _2310_/A1 vssd1 vssd1 vccd1 vccd1 sky130_fd_sc_hd__diode_2
XFILLER_70_131 vssd1 vssd1 vccd1 vccd1 sky130_fd_sc_hd__fill_1
XFILLER_43_389 vssd1 vssd1 vccd1 vccd1 sky130_fd_sc_hd__decap_3
XFILLER_70_197 vssd1 vssd1 vccd1 vccd1 sky130_fd_sc_hd__decap_6
XTAP_TAPCELL_ROW_41_557 vssd1 vccd1 sky130_fd_sc_hd__tapvpwrvgnd_1
XFILLER_7_213 vssd1 vssd1 vccd1 vccd1 sky130_fd_sc_hd__decap_8
XFILLER_3_485 vccd1 vssd1 vccd1 vssd1 sky130_ef_sc_hd__decap_12
XFILLER_19_397 vssd1 vssd1 vccd1 vccd1 sky130_fd_sc_hd__fill_1
XFILLER_34_312 vssd1 vssd1 vccd1 vccd1 sky130_fd_sc_hd__fill_1
XFILLER_34_334 vssd1 vssd1 vccd1 vccd1 sky130_fd_sc_hd__fill_2
XANTENNA__4199__A_N _4258_/C vssd1 vssd1 vccd1 vccd1 sky130_fd_sc_hd__diode_2
X_2972_ _4763_/Q _4778_/Q _2975_/A _2952_/B vssd1 vssd1 vccd1 vccd1 _2979_/A sky130_fd_sc_hd__a31o_1
X_4711_ _4744_/CLK _4711_/D fanout391/X vssd1 vssd1 vccd1 vccd1 _4711_/Q sky130_fd_sc_hd__dfrtp_1
X_4642_ _4644_/CLK _4642_/D fanout429/X vssd1 vssd1 vccd1 vccd1 _4642_/Q sky130_fd_sc_hd__dfrtp_1
X_4573_ _4575_/CLK _4573_/D fanout438/X vssd1 vssd1 vccd1 vccd1 _4573_/Q sky130_fd_sc_hd__dfrtp_2
X_3524_ _3524_/A _3524_/B _3524_/C vssd1 vssd1 vccd1 vccd1 _3524_/Y sky130_fd_sc_hd__nand3_1
X_3455_ _4604_/Q _3504_/A2 _3477_/B1 _3923_/A vssd1 vssd1 vccd1 vccd1 _3455_/X sky130_fd_sc_hd__o211a_1
X_2406_ hold15/X _2405_/X _2420_/S vssd1 vssd1 vccd1 vccd1 _4498_/D sky130_fd_sc_hd__mux2_1
XFILLER_69_242 vccd1 vssd1 vccd1 vssd1 sky130_ef_sc_hd__decap_12
XANTENNA__3561__B _3613_/B vssd1 vssd1 vccd1 vccd1 sky130_fd_sc_hd__diode_2
X_3386_ _3279_/B _3380_/A _3380_/B _3243_/Y vssd1 vssd1 vccd1 vccd1 _3386_/X sky130_fd_sc_hd__a31o_1
XFILLER_69_286 vssd1 vssd1 vccd1 vccd1 sky130_fd_sc_hd__fill_1
XTAP_TAPCELL_ROW_4_227 vssd1 vccd1 sky130_fd_sc_hd__tapvpwrvgnd_1
X_2337_ _2336_/Y _2335_/X _2334_/X hold205/X _4038_/B1 vssd1 vssd1 vccd1 vccd1 _4466_/D
+ sky130_fd_sc_hd__o32a_1
XFILLER_29_117 vssd1 vssd1 vccd1 vccd1 sky130_fd_sc_hd__decap_6
X_2268_ hold47/X _4576_/Q _2271_/S vssd1 vssd1 vccd1 vccd1 _4447_/D sky130_fd_sc_hd__mux2_1
XANTENNA__3988__S _4123_/S vssd1 vssd1 vccd1 vccd1 sky130_fd_sc_hd__diode_2
X_4007_ _4006_/Y _4005_/X _4004_/X hold161/X _4007_/B2 vssd1 vssd1 vccd1 vccd1 _4693_/D
+ sky130_fd_sc_hd__o32a_1
XTAP_TAPCELL_ROW_83_936 vssd1 vccd1 sky130_fd_sc_hd__tapvpwrvgnd_1
XFILLER_25_301 vssd1 vssd1 vccd1 vccd1 sky130_fd_sc_hd__fill_2
XFILLER_37_161 vssd1 vssd1 vccd1 vccd1 sky130_fd_sc_hd__decap_6
XFILLER_52_197 vccd1 vssd1 vccd1 vssd1 sky130_ef_sc_hd__decap_12
XFILLER_4_205 vssd1 vssd1 vccd1 vccd1 sky130_fd_sc_hd__fill_1
XFILLER_0_411 vssd1 vssd1 vccd1 vccd1 sky130_fd_sc_hd__decap_4
XFILLER_0_477 vccd1 vssd1 vccd1 vssd1 sky130_ef_sc_hd__decap_12
XANTENNA__4059__S _4064_/D vssd1 vssd1 vccd1 vccd1 sky130_fd_sc_hd__diode_2
Xhold30 hold30/A vssd1 vssd1 vccd1 vccd1 hold30/X sky130_fd_sc_hd__dlygate4sd3_1
Xhold41 hold41/A vssd1 vssd1 vccd1 vccd1 hold41/X sky130_fd_sc_hd__dlygate4sd3_1
Xhold74 hold74/A vssd1 vssd1 vccd1 vccd1 hold74/X sky130_fd_sc_hd__dlygate4sd3_1
Xhold52 hold52/A vssd1 vssd1 vccd1 vccd1 hold52/X sky130_fd_sc_hd__dlygate4sd3_1
Xhold63 hold63/A vssd1 vssd1 vccd1 vccd1 hold63/X sky130_fd_sc_hd__dlygate4sd3_1
XFILLER_75_223 vssd1 vssd1 vccd1 vccd1 sky130_fd_sc_hd__fill_1
XFILLER_29_96 vccd1 vssd1 vccd1 vssd1 sky130_ef_sc_hd__decap_12
Xhold85 hold85/A vssd1 vssd1 vccd1 vccd1 hold85/X sky130_fd_sc_hd__dlygate4sd3_1
Xhold96 hold96/A vssd1 vssd1 vccd1 vccd1 hold96/X sky130_fd_sc_hd__dlygate4sd3_1
XANTENNA_input18_A s_axis_tdata[23] vssd1 vssd1 vccd1 vccd1 sky130_fd_sc_hd__diode_2
XANTENNA__3898__S _4314_/S vssd1 vssd1 vccd1 vccd1 sky130_fd_sc_hd__diode_2
XTAP_TAPCELL_ROW_46_605 vssd1 vccd1 sky130_fd_sc_hd__tapvpwrvgnd_1
XFILLER_56_470 vssd1 vssd1 vccd1 vccd1 sky130_fd_sc_hd__decap_6
XFILLER_16_356 vssd1 vssd1 vccd1 vccd1 sky130_fd_sc_hd__decap_8
XFILLER_16_389 vccd1 vssd1 vccd1 vssd1 sky130_ef_sc_hd__decap_12
XTAP_TAPCELL_ROW_54_671 vssd1 vccd1 sky130_fd_sc_hd__tapvpwrvgnd_1
XFILLER_31_337 vssd1 vssd1 vccd1 vccd1 sky130_fd_sc_hd__fill_2
XFILLER_6_67 vccd1 vssd1 vccd1 vssd1 sky130_ef_sc_hd__decap_12
XANTENNA__4192__A1 _4324_/A vssd1 vssd1 vccd1 vccd1 sky130_fd_sc_hd__diode_2
X_3240_ _4551_/Q _4592_/Q vssd1 vssd1 vccd1 vccd1 _3242_/B sky130_fd_sc_hd__or2_1
X_3171_ _4570_/Q _4611_/Q vssd1 vssd1 vccd1 vccd1 _3187_/C sky130_fd_sc_hd__nand2_1
XFILLER_66_201 vssd1 vssd1 vccd1 vccd1 sky130_fd_sc_hd__fill_1
XFILLER_19_150 vssd1 vssd1 vccd1 vccd1 sky130_fd_sc_hd__decap_6
XFILLER_81_237 vccd1 vssd1 vccd1 vssd1 sky130_ef_sc_hd__decap_12
XFILLER_54_429 vssd1 vssd1 vccd1 vccd1 sky130_fd_sc_hd__fill_1
XTAP_TAPCELL_ROW_80_906 vssd1 vccd1 sky130_fd_sc_hd__tapvpwrvgnd_1
XFILLER_62_451 vssd1 vssd1 vccd1 vccd1 sky130_fd_sc_hd__decap_3
XTAP_TAPCELL_ROW_17_340 vssd1 vccd1 sky130_fd_sc_hd__tapvpwrvgnd_1
X_2955_ _2944_/X _2954_/Y _2985_/A2 vssd1 vssd1 vccd1 vccd1 _2955_/Y sky130_fd_sc_hd__o21ai_1
X_2886_ _2848_/A _2847_/A _2847_/B _2842_/A vssd1 vssd1 vccd1 vccd1 _2897_/A sky130_fd_sc_hd__a31oi_2
X_4625_ _4631_/CLK _4625_/D fanout410/X vssd1 vssd1 vccd1 vccd1 _4625_/Q sky130_fd_sc_hd__dfrtp_1
X_4556_ _4668_/CLK _4556_/D fanout423/X vssd1 vssd1 vccd1 vccd1 _4556_/Q sky130_fd_sc_hd__dfrtp_1
X_3507_ _3507_/A _3507_/B vssd1 vssd1 vccd1 vccd1 _3507_/Y sky130_fd_sc_hd__nand2_1
X_4487_ _4820_/CLK _4487_/D fanout432/X vssd1 vssd1 vccd1 vccd1 hold5/A sky130_fd_sc_hd__dfrtp_1
X_3438_ _3460_/A1 _3437_/Y _3460_/B1 vssd1 vssd1 vccd1 vccd1 _3438_/X sky130_fd_sc_hd__a21o_1
X_3369_ _3370_/A _3370_/B _3370_/C _3370_/D vssd1 vssd1 vccd1 vccd1 _3371_/A sky130_fd_sc_hd__a22oi_1
XFILLER_17_109 vssd1 vssd1 vccd1 vccd1 sky130_fd_sc_hd__decap_3
XANTENNA_fanout362_X _3794_/A0 vssd1 vssd1 vccd1 vccd1 sky130_fd_sc_hd__diode_2
XFILLER_82_27 vssd1 vssd1 vccd1 vccd1 sky130_fd_sc_hd__fill_1
XFILLER_40_167 vccd1 vssd1 vccd1 vssd1 sky130_ef_sc_hd__decap_12
XTAP_TAPCELL_ROW_51_652 vssd1 vccd1 sky130_fd_sc_hd__tapvpwrvgnd_1
XTAP_TAPCELL_ROW_23_398 vssd1 vccd1 sky130_fd_sc_hd__tapvpwrvgnd_1
Xoutput42 hold1/A vssd1 vssd1 vccd1 vccd1 m_axis_tdata[14] sky130_fd_sc_hd__buf_2
Xoutput64 hold12/A vssd1 vssd1 vccd1 vccd1 m_axis_tdata[34] sky130_fd_sc_hd__buf_2
Xoutput75 hold13/A vssd1 vssd1 vccd1 vccd1 m_axis_tdata[8] sky130_fd_sc_hd__buf_2
Xoutput53 hold44/A vssd1 vssd1 vccd1 vccd1 m_axis_tdata[24] sky130_fd_sc_hd__buf_2
XFILLER_0_285 vccd1 vssd1 vccd1 vssd1 sky130_ef_sc_hd__decap_12
XANTENNA__3988__A1 _4020_/A1 vssd1 vssd1 vccd1 vccd1 sky130_fd_sc_hd__diode_2
XFILLER_16_153 vccd1 vssd1 vccd1 vssd1 sky130_ef_sc_hd__decap_12
XFILLER_71_281 vssd1 vssd1 vccd1 vccd1 sky130_fd_sc_hd__fill_2
XFILLER_16_186 vssd1 vssd1 vccd1 vccd1 sky130_fd_sc_hd__decap_8
XFILLER_31_167 vssd1 vssd1 vccd1 vccd1 sky130_fd_sc_hd__fill_1
X_2740_ _4743_/Q _4713_/Q vssd1 vssd1 vccd1 vccd1 _2740_/X sky130_fd_sc_hd__and2_1
XFILLER_8_363 vssd1 vssd1 vccd1 vccd1 sky130_fd_sc_hd__fill_1
X_2671_ _4741_/Q _4711_/Q vssd1 vssd1 vccd1 vccd1 _2672_/B sky130_fd_sc_hd__nor2_1
X_4410_ _4819_/Q input27/X _4410_/S vssd1 vssd1 vccd1 vccd1 _4819_/D sky130_fd_sc_hd__mux2_1
XFILLER_8_396 vssd1 vssd1 vccd1 vccd1 sky130_fd_sc_hd__fill_2
XANTENNA__4165__A1 _4231_/C vssd1 vssd1 vccd1 vccd1 sky130_fd_sc_hd__diode_2
X_4341_ _4340_/A _4328_/C _4328_/B _4376_/A2 _4340_/Y vssd1 vssd1 vccd1 vccd1 _4341_/X
+ sky130_fd_sc_hd__a311o_1
Xfanout309 _4799_/Q vssd1 vssd1 vccd1 vccd1 _4360_/A sky130_fd_sc_hd__buf_2
X_4272_ _4271_/Y _4270_/X _4269_/X hold200/X _4280_/B2 vssd1 vssd1 vccd1 vccd1 _4760_/D
+ sky130_fd_sc_hd__o32a_1
XFILLER_86_307 vssd1 vssd1 vccd1 vccd1 sky130_fd_sc_hd__fill_1
X_3223_ _4555_/Q _4596_/Q vssd1 vssd1 vccd1 vccd1 _3226_/C sky130_fd_sc_hd__nand2_1
XFILLER_39_223 vssd1 vssd1 vccd1 vccd1 sky130_fd_sc_hd__fill_1
X_3154_ _3155_/B vssd1 vssd1 vccd1 vccd1 _3154_/Y sky130_fd_sc_hd__inv_2
XFILLER_39_256 vssd1 vssd1 vccd1 vccd1 sky130_fd_sc_hd__decap_8
XFILLER_82_513 vssd1 vssd1 vccd1 vccd1 sky130_fd_sc_hd__decap_6
X_3085_ _3151_/A _3085_/B _3085_/C vssd1 vssd1 vccd1 vccd1 _3087_/C sky130_fd_sc_hd__nand3_4
XFILLER_54_259 vccd1 vssd1 vccd1 vssd1 sky130_ef_sc_hd__decap_12
XTAP_TAPCELL_ROW_65_777 vssd1 vccd1 sky130_fd_sc_hd__tapvpwrvgnd_1
X_3987_ _3986_/Y _3985_/X _3984_/X hold143/X _3999_/B2 vssd1 vssd1 vccd1 vccd1 _4688_/D
+ sky130_fd_sc_hd__o32a_1
XFILLER_22_167 vssd1 vssd1 vccd1 vccd1 sky130_fd_sc_hd__fill_2
X_2938_ _2938_/A _2938_/B vssd1 vssd1 vccd1 vccd1 _2939_/B sky130_fd_sc_hd__nor2_1
XANTENNA_fanout322_A _2311_/A vssd1 vssd1 vccd1 vccd1 sky130_fd_sc_hd__diode_2
XFILLER_22_189 vssd1 vssd1 vccd1 vccd1 sky130_fd_sc_hd__decap_3
X_2869_ _4702_/Q _2869_/B vssd1 vssd1 vccd1 vccd1 _2872_/B sky130_fd_sc_hd__nand2b_1
XTAP_TAPCELL_ROW_20_368 vssd1 vccd1 sky130_fd_sc_hd__tapvpwrvgnd_1
X_4608_ _4609_/CLK _4608_/D fanout429/X vssd1 vssd1 vccd1 vccd1 _4608_/Q sky130_fd_sc_hd__dfrtp_1
X_4539_ _4668_/CLK _4539_/D fanout422/X vssd1 vssd1 vccd1 vccd1 _4539_/Q sky130_fd_sc_hd__dfrtp_1
XANTENNA__2410__S _2424_/S vssd1 vssd1 vccd1 vccd1 sky130_fd_sc_hd__diode_2
XANTENNA__3419__B1 _3541_/B1 vssd1 vssd1 vccd1 vccd1 sky130_fd_sc_hd__diode_2
XFILLER_45_259 vssd1 vssd1 vccd1 vccd1 sky130_fd_sc_hd__fill_2
XFILLER_26_75 vssd1 vssd1 vccd1 vccd1 sky130_fd_sc_hd__decap_6
XFILLER_26_462 vssd1 vssd1 vccd1 vccd1 sky130_fd_sc_hd__fill_2
XFILLER_60_229 vssd1 vssd1 vccd1 vccd1 sky130_fd_sc_hd__decap_3
XFILLER_9_149 vssd1 vssd1 vccd1 vccd1 sky130_fd_sc_hd__decap_3
XFILLER_9_138 vssd1 vssd1 vccd1 vccd1 sky130_fd_sc_hd__fill_1
XANTENNA__2812__C _2812_/C vssd1 vssd1 vccd1 vccd1 sky130_fd_sc_hd__diode_2
XANTENNA_clkbuf_leaf_5_clk_A clkload0/A vssd1 vssd1 vccd1 vccd1 sky130_fd_sc_hd__diode_2
XANTENNA__4147__A1 _4167_/A1 vssd1 vssd1 vccd1 vccd1 sky130_fd_sc_hd__diode_2
XFILLER_3_35 vccd1 vssd1 vccd1 vssd1 sky130_ef_sc_hd__decap_12
XFILLER_3_57 vssd1 vssd1 vccd1 vccd1 sky130_fd_sc_hd__fill_1
XFILLER_3_79 vssd1 vssd1 vccd1 vccd1 sky130_fd_sc_hd__fill_1
XFILLER_76_373 vssd1 vssd1 vccd1 vccd1 sky130_fd_sc_hd__decap_3
XFILLER_76_362 vssd1 vssd1 vccd1 vccd1 sky130_fd_sc_hd__fill_2
XFILLER_51_218 vssd1 vssd1 vccd1 vccd1 sky130_fd_sc_hd__decap_6
X_3910_ _4172_/B _4168_/C _4223_/D vssd1 vssd1 vccd1 vccd1 _3910_/X sky130_fd_sc_hd__or3b_1
XTAP_TAPCELL_ROW_62_747 vssd1 vccd1 sky130_fd_sc_hd__tapvpwrvgnd_1
XANTENNA__3968__A1_N _4037_/D vssd1 vssd1 vccd1 vccd1 sky130_fd_sc_hd__diode_2
XFILLER_32_421 vccd1 vssd1 vccd1 vssd1 sky130_ef_sc_hd__decap_12
XFILLER_44_281 vssd1 vssd1 vccd1 vccd1 sky130_fd_sc_hd__fill_1
X_3841_ _2971_/Y _2983_/Y _2984_/Y vssd1 vssd1 vccd1 vccd1 _3841_/Y sky130_fd_sc_hd__a21oi_1
XFILLER_80_3 vssd1 vssd1 vccd1 vccd1 sky130_fd_sc_hd__fill_1
X_3772_ _4535_/Q _4644_/Q _3768_/Y vssd1 vssd1 vccd1 vccd1 _3774_/A sky130_fd_sc_hd__a21oi_1
XANTENNA__2291__A _4119_/S vssd1 vssd1 vccd1 vccd1 sky130_fd_sc_hd__diode_2
X_2723_ _2723_/A _2723_/B vssd1 vssd1 vccd1 vccd1 _3825_/A sky130_fd_sc_hd__nor2_1
X_2654_ _3821_/A _3821_/B _3830_/A2 vssd1 vssd1 vccd1 vccd1 _2654_/Y sky130_fd_sc_hd__a21oi_1
X_2585_ _2583_/Y _2585_/B vssd1 vssd1 vccd1 vccd1 _2585_/Y sky130_fd_sc_hd__nand2b_1
X_4324_ _4324_/A _4344_/B vssd1 vssd1 vccd1 vccd1 _4324_/Y sky130_fd_sc_hd__nor2_1
Xfanout117 _2427_/X vssd1 vssd1 vccd1 vccd1 _2797_/A2 sky130_fd_sc_hd__clkbuf_2
Xfanout106 _3162_/Y vssd1 vssd1 vccd1 vccd1 _3534_/A2 sky130_fd_sc_hd__clkbuf_2
Xfanout128 _4376_/A2 vssd1 vssd1 vccd1 vccd1 _4314_/S sky130_fd_sc_hd__clkbuf_2
Xfanout139 _4138_/B1 vssd1 vssd1 vccd1 vccd1 _4015_/B2 sky130_fd_sc_hd__clkbuf_2
X_4255_ _4320_/A _4279_/A2 _4264_/B2 vssd1 vssd1 vccd1 vccd1 _4255_/Y sky130_fd_sc_hd__o21ai_1
X_4186_ _4214_/A0 _4210_/A1 _4324_/A vssd1 vssd1 vccd1 vccd1 _4186_/X sky130_fd_sc_hd__mux2_1
X_3206_ _4559_/Q _4600_/Q vssd1 vssd1 vccd1 vccd1 _3207_/B sky130_fd_sc_hd__nor2_1
X_3137_ _3135_/Y _3136_/Y _3126_/X _3156_/B1 vssd1 vssd1 vccd1 vccd1 _3138_/A sky130_fd_sc_hd__o31a_1
XTAP_TAPCELL_ROW_78_891 vssd1 vccd1 sky130_fd_sc_hd__tapvpwrvgnd_1
XFILLER_67_384 vssd1 vssd1 vccd1 vccd1 sky130_fd_sc_hd__fill_1
XFILLER_67_373 vssd1 vssd1 vccd1 vccd1 sky130_fd_sc_hd__decap_3
XFILLER_55_502 vssd1 vssd1 vccd1 vccd1 sky130_fd_sc_hd__fill_2
XFILLER_82_365 vccd1 vssd1 vccd1 vssd1 sky130_ef_sc_hd__decap_12
X_3068_ _3026_/B _3019_/X _3021_/A _3067_/B vssd1 vssd1 vccd1 vccd1 _3069_/B sky130_fd_sc_hd__o211ai_1
XFILLER_63_18 vssd1 vssd1 vccd1 vccd1 sky130_fd_sc_hd__decap_4
XANTENNA__3996__S _4063_/S vssd1 vssd1 vccd1 vccd1 sky130_fd_sc_hd__diode_2
XTAP_TAPCELL_ROW_25_416 vssd1 vccd1 sky130_fd_sc_hd__tapvpwrvgnd_1
XFILLER_50_251 vssd1 vssd1 vccd1 vccd1 sky130_fd_sc_hd__fill_1
XANTENNA__2405__S _2421_/S vssd1 vssd1 vccd1 vccd1 sky130_fd_sc_hd__diode_2
XTAP_TAPCELL_ROW_33_482 vssd1 vccd1 sky130_fd_sc_hd__tapvpwrvgnd_1
XANTENNA_fanout325_X _4340_/A vssd1 vssd1 vccd1 vccd1 sky130_fd_sc_hd__diode_2
XFILLER_12_33 vssd1 vssd1 vccd1 vccd1 sky130_fd_sc_hd__fill_1
XANTENNA__4129__A1 _4323_/S vssd1 vssd1 vccd1 vccd1 sky130_fd_sc_hd__diode_2
Xhold171 _4631_/Q vssd1 vssd1 vccd1 vccd1 hold171/X sky130_fd_sc_hd__dlygate4sd3_1
Xhold160 _4776_/Q vssd1 vssd1 vccd1 vccd1 hold160/X sky130_fd_sc_hd__dlygate4sd3_1
Xhold182 _4752_/Q vssd1 vssd1 vccd1 vccd1 hold182/X sky130_fd_sc_hd__dlygate4sd3_1
Xhold193 _4628_/Q vssd1 vssd1 vccd1 vccd1 hold193/X sky130_fd_sc_hd__dlygate4sd3_1
XFILLER_58_340 vccd1 vssd1 vccd1 vssd1 sky130_ef_sc_hd__decap_12
XANTENNA__4067__S _4274_/D vssd1 vssd1 vccd1 vccd1 sky130_fd_sc_hd__diode_2
XFILLER_58_373 vssd1 vssd1 vccd1 vccd1 sky130_fd_sc_hd__fill_2
XFILLER_61_505 vssd1 vssd1 vccd1 vccd1 sky130_fd_sc_hd__fill_1
XFILLER_14_421 vccd1 vssd1 vccd1 vssd1 sky130_ef_sc_hd__decap_12
XFILLER_33_229 vssd1 vssd1 vccd1 vccd1 sky130_fd_sc_hd__fill_1
XFILLER_41_251 vssd1 vssd1 vccd1 vccd1 sky130_fd_sc_hd__fill_1
XFILLER_53_40 vssd1 vssd1 vccd1 vccd1 sky130_fd_sc_hd__fill_1
XFILLER_41_262 vssd1 vssd1 vccd1 vccd1 sky130_fd_sc_hd__fill_1
XANTENNA__3879__A0 _4020_/A0 vssd1 vssd1 vccd1 vccd1 sky130_fd_sc_hd__diode_2
X_2370_ hold7/X _2369_/X _2382_/S vssd1 vssd1 vccd1 vccd1 _4480_/D sky130_fd_sc_hd__mux2_1
XFILLER_78_81 vssd1 vssd1 vccd1 vccd1 sky130_fd_sc_hd__decap_3
XFILLER_68_126 vssd1 vssd1 vccd1 vccd1 sky130_fd_sc_hd__fill_1
XFILLER_68_159 vssd1 vssd1 vccd1 vccd1 sky130_fd_sc_hd__fill_1
X_4040_ _3977_/C _3976_/D _3977_/B _4036_/S vssd1 vssd1 vccd1 vccd1 _4040_/X sky130_fd_sc_hd__a22o_1
XFILLER_49_373 vssd1 vssd1 vccd1 vccd1 sky130_fd_sc_hd__fill_2
XTAP_TAPCELL_ROW_75_861 vssd1 vccd1 sky130_fd_sc_hd__tapvpwrvgnd_1
XFILLER_64_365 vssd1 vssd1 vccd1 vccd1 sky130_fd_sc_hd__decap_3
XFILLER_17_270 vssd1 vssd1 vccd1 vccd1 sky130_fd_sc_hd__decap_8
XFILLER_17_281 vccd1 vssd1 vccd1 vssd1 sky130_ef_sc_hd__decap_12
XFILLER_20_446 vssd1 vssd1 vccd1 vccd1 sky130_fd_sc_hd__fill_2
X_3824_ hold156/X _3830_/A2 _3823_/Y _2692_/X vssd1 vssd1 vccd1 vccd1 _4630_/D sky130_fd_sc_hd__o2bb2ai_1
X_3755_ _3754_/A _3754_/B _3756_/B vssd1 vssd1 vccd1 vccd1 _3755_/X sky130_fd_sc_hd__o21a_1
XTAP_TAPCELL_ROW_30_463 vssd1 vccd1 sky130_fd_sc_hd__tapvpwrvgnd_1
X_2706_ _2706_/A _2706_/B vssd1 vssd1 vccd1 vccd1 _2711_/A sky130_fd_sc_hd__nand2_1
X_3686_ _4526_/Q _4635_/Q _4525_/Q _4634_/Q vssd1 vssd1 vccd1 vccd1 _3686_/X sky130_fd_sc_hd__o211a_1
XPHY_EDGE_ROW_12_Right_12 vssd1 vssd1 vccd1 vccd1 sky130_fd_sc_hd__decap_3
X_2637_ _4725_/Q _2637_/B vssd1 vssd1 vccd1 vccd1 _2637_/Y sky130_fd_sc_hd__xnor2_1
XANTENNA_fanout118_A _2930_/A2 vssd1 vssd1 vccd1 vccd1 sky130_fd_sc_hd__diode_2
X_2568_ _4738_/Q _4708_/Q vssd1 vssd1 vccd1 vccd1 _2617_/A sky130_fd_sc_hd__nand2_1
XFILLER_87_446 vssd1 vssd1 vccd1 vccd1 sky130_fd_sc_hd__fill_2
X_4307_ _4371_/A _4307_/A2 _4378_/B2 vssd1 vssd1 vccd1 vccd1 _4307_/Y sky130_fd_sc_hd__o21ai_1
X_2499_ _4720_/Q _4705_/Q vssd1 vssd1 vccd1 vccd1 _2501_/B sky130_fd_sc_hd__xor2_1
XFILLER_59_104 vssd1 vssd1 vccd1 vccd1 sky130_fd_sc_hd__decap_3
XFILLER_59_137 vssd1 vssd1 vccd1 vccd1 sky130_fd_sc_hd__decap_3
X_4238_ _4238_/A0 _4238_/A1 _4238_/S vssd1 vssd1 vccd1 vccd1 _4238_/X sky130_fd_sc_hd__mux2_1
X_4169_ _4302_/D _4176_/A2 _4240_/B1 vssd1 vssd1 vccd1 vccd1 _4169_/Y sky130_fd_sc_hd__o21ai_1
XTAP_TAPCELL_ROW_38_530 vssd1 vccd1 sky130_fd_sc_hd__tapvpwrvgnd_1
XANTENNA__4047__A0 _4099_/A0 vssd1 vssd1 vccd1 vccd1 sky130_fd_sc_hd__diode_2
XPHY_EDGE_ROW_21_Right_21 vssd1 vssd1 vccd1 vccd1 sky130_fd_sc_hd__decap_3
XFILLER_23_240 vssd1 vssd1 vccd1 vccd1 sky130_fd_sc_hd__decap_3
XFILLER_23_273 vssd1 vssd1 vccd1 vccd1 sky130_fd_sc_hd__decap_6
XPHY_EDGE_ROW_30_Right_30 vssd1 vssd1 vccd1 vccd1 sky130_fd_sc_hd__decap_3
XFILLER_48_95 vssd1 vssd1 vccd1 vccd1 sky130_fd_sc_hd__decap_8
XFILLER_46_343 vccd1 vssd1 vccd1 vssd1 sky130_ef_sc_hd__decap_12
XFILLER_58_181 vssd1 vssd1 vccd1 vccd1 sky130_fd_sc_hd__decap_3
XFILLER_61_324 vccd1 vssd1 vccd1 vssd1 sky130_ef_sc_hd__decap_12
XTAP_TAPCELL_ROW_44_588 vssd1 vccd1 sky130_fd_sc_hd__tapvpwrvgnd_1
XFILLER_80_60 vccd1 vssd1 vccd1 vssd1 sky130_ef_sc_hd__decap_12
X_3540_ _3331_/X _3539_/X _3503_/X _4580_/Q _3540_/B2 vssd1 vssd1 vccd1 vccd1 _4580_/D
+ sky130_fd_sc_hd__a32o_1
XANTENNA__4199__C _4266_/D vssd1 vssd1 vccd1 vccd1 sky130_fd_sc_hd__diode_2
X_3471_ _4607_/Q _3503_/A2 _3477_/B1 _3543_/A vssd1 vssd1 vccd1 vccd1 _3471_/X sky130_fd_sc_hd__o211a_1
X_2422_ hold55/X _2421_/X _2424_/S vssd1 vssd1 vccd1 vccd1 _4506_/D sky130_fd_sc_hd__mux2_1
XFILLER_43_3 vssd1 vssd1 vccd1 vccd1 sky130_fd_sc_hd__decap_4
X_2353_ _4544_/Q hold45/A _2365_/S vssd1 vssd1 vccd1 vccd1 _2353_/X sky130_fd_sc_hd__mux2_1
X_2284_ _3981_/D _2295_/C _2295_/B _3900_/B _2281_/X vssd1 vssd1 vccd1 vccd1 _2284_/X
+ sky130_fd_sc_hd__a311o_1
X_4023_ _4022_/Y _4021_/X _4020_/X hold142/X _4039_/B2 vssd1 vssd1 vccd1 vccd1 _4697_/D
+ sky130_fd_sc_hd__o32a_1
XFILLER_49_181 vssd1 vssd1 vccd1 vccd1 sky130_fd_sc_hd__fill_1
XTAP_TAPCELL_ROW_35_500 vssd1 vccd1 sky130_fd_sc_hd__tapvpwrvgnd_1
X_3807_ _2489_/A _2472_/Y _2474_/Y vssd1 vssd1 vccd1 vccd1 _3807_/Y sky130_fd_sc_hd__o21ai_1
XFILLER_20_265 vccd1 vssd1 vccd1 vssd1 sky130_ef_sc_hd__decap_12
XANTENNA_clkbuf_leaf_30_clk_A clkbuf_2_3__f_clk/X vssd1 vssd1 vccd1 vccd1 sky130_fd_sc_hd__diode_2
X_4787_ _4819_/CLK _4787_/D fanout403/X vssd1 vssd1 vccd1 vccd1 _4787_/Q sky130_fd_sc_hd__dfrtp_1
XANTENNA_fanout402_A fanout404/X vssd1 vssd1 vccd1 vccd1 sky130_fd_sc_hd__diode_2
X_3738_ _4532_/Q _4641_/Q vssd1 vssd1 vccd1 vccd1 _3743_/D sky130_fd_sc_hd__nor2_1
X_3669_ _3690_/B _3690_/C vssd1 vssd1 vccd1 vccd1 _3670_/B sky130_fd_sc_hd__nor2_1
XANTENNA_clkbuf_leaf_45_clk_A clkload0/A vssd1 vssd1 vccd1 vccd1 sky130_fd_sc_hd__diode_2
XFILLER_87_221 vssd1 vssd1 vccd1 vccd1 sky130_fd_sc_hd__decap_3
XANTENNA__3712__C1 _3923_/A vssd1 vssd1 vccd1 vccd1 sky130_fd_sc_hd__diode_2
XFILLER_87_265 vccd1 vssd1 vccd1 vssd1 sky130_ef_sc_hd__decap_12
XFILLER_85_27 vccd1 vssd1 vccd1 vssd1 sky130_ef_sc_hd__decap_12
XTAP_TAPCELL_ROW_86_967 vssd1 vccd1 sky130_fd_sc_hd__tapvpwrvgnd_1
XFILLER_75_449 vccd1 vssd1 vccd1 vssd1 sky130_ef_sc_hd__decap_12
XFILLER_75_438 vssd1 vssd1 vccd1 vccd1 sky130_fd_sc_hd__fill_1
XFILLER_28_321 vssd1 vssd1 vccd1 vccd1 sky130_fd_sc_hd__decap_6
XFILLER_18_65 vssd1 vssd1 vccd1 vccd1 sky130_fd_sc_hd__fill_1
XFILLER_28_343 vccd1 vssd1 vccd1 vssd1 sky130_ef_sc_hd__decap_12
XFILLER_28_365 vccd1 vssd1 vccd1 vssd1 sky130_ef_sc_hd__decap_12
XFILLER_43_346 vccd1 vssd1 vccd1 vssd1 sky130_ef_sc_hd__decap_12
XANTENNA__4120__A_N _4199_/D vssd1 vssd1 vccd1 vccd1 sky130_fd_sc_hd__diode_2
XFILLER_11_210 vssd1 vssd1 vccd1 vccd1 sky130_fd_sc_hd__decap_4
XTAP_TAPCELL_ROW_41_558 vssd1 vccd1 sky130_fd_sc_hd__tapvpwrvgnd_1
XFILLER_11_298 vssd1 vssd1 vccd1 vccd1 sky130_fd_sc_hd__decap_4
XANTENNA__3951__C1 _3928_/S vssd1 vssd1 vccd1 vccd1 sky130_fd_sc_hd__diode_2
XFILLER_3_497 vssd1 vssd1 vccd1 vccd1 sky130_fd_sc_hd__decap_6
XFILLER_78_265 vssd1 vssd1 vccd1 vccd1 sky130_fd_sc_hd__fill_2
XFILLER_15_7 vssd1 vssd1 vccd1 vccd1 sky130_fd_sc_hd__fill_1
XFILLER_75_93 vccd1 vssd1 vccd1 vssd1 sky130_ef_sc_hd__decap_12
XFILLER_34_302 vssd1 vssd1 vccd1 vccd1 sky130_fd_sc_hd__fill_1
XFILLER_61_143 vssd1 vssd1 vccd1 vccd1 sky130_fd_sc_hd__fill_2
X_2971_ _2971_/A _2971_/B vssd1 vssd1 vccd1 vccd1 _2971_/Y sky130_fd_sc_hd__xnor2_1
XFILLER_61_165 vssd1 vssd1 vccd1 vccd1 sky130_fd_sc_hd__decap_3
XFILLER_61_154 vssd1 vssd1 vccd1 vccd1 sky130_fd_sc_hd__decap_3
X_4710_ clkload7/A _4710_/D fanout380/X vssd1 vssd1 vccd1 vccd1 hold98/A sky130_fd_sc_hd__dfrtp_1
X_4641_ _4644_/CLK _4641_/D fanout428/X vssd1 vssd1 vccd1 vccd1 _4641_/Q sky130_fd_sc_hd__dfrtp_1
X_4572_ _4575_/CLK _4572_/D fanout439/X vssd1 vssd1 vccd1 vccd1 _4572_/Q sky130_fd_sc_hd__dfrtp_2
XTAP_TAPCELL_ROW_12_293 vssd1 vccd1 sky130_fd_sc_hd__tapvpwrvgnd_1
X_3523_ _3524_/B _3524_/C _3524_/A vssd1 vssd1 vccd1 vccd1 _3523_/X sky130_fd_sc_hd__a21o_1
X_3454_ _3460_/A1 _3452_/X _3453_/Y _3460_/B1 vssd1 vssd1 vccd1 vccd1 _3454_/X sky130_fd_sc_hd__a31o_1
X_2405_ _4570_/Q hold60/A _2421_/S vssd1 vssd1 vccd1 vccd1 _2405_/X sky130_fd_sc_hd__mux2_1
X_3385_ _4550_/Q _3396_/A2 _3383_/X _3384_/X vssd1 vssd1 vccd1 vccd1 _4550_/D sky130_fd_sc_hd__a22o_1
XFILLER_69_254 vssd1 vssd1 vccd1 vccd1 sky130_fd_sc_hd__decap_6
XTAP_TAPCELL_ROW_4_228 vssd1 vccd1 sky130_fd_sc_hd__tapvpwrvgnd_1
X_2336_ _4033_/D _2338_/B _4038_/B1 vssd1 vssd1 vccd1 vccd1 _2336_/Y sky130_fd_sc_hd__o21ai_1
XFILLER_57_405 vccd1 vssd1 vccd1 vssd1 sky130_ef_sc_hd__decap_12
X_2267_ hold65/X _4575_/Q _2271_/S vssd1 vssd1 vccd1 vccd1 _4446_/D sky130_fd_sc_hd__mux2_1
Xclkbuf_leaf_49_clk clkload0/A vssd1 vssd1 vccd1 vccd1 _4806_/CLK sky130_fd_sc_hd__clkbuf_8
XFILLER_57_449 vccd1 vssd1 vccd1 vssd1 sky130_ef_sc_hd__decap_12
XFILLER_72_408 vssd1 vssd1 vccd1 vccd1 sky130_fd_sc_hd__fill_1
X_4006_ _4005_/D _4022_/A2 _4007_/B2 vssd1 vssd1 vccd1 vccd1 _4006_/Y sky130_fd_sc_hd__o21ai_1
XTAP_TAPCELL_ROW_83_937 vssd1 vccd1 sky130_fd_sc_hd__tapvpwrvgnd_1
XFILLER_25_324 vssd1 vssd1 vccd1 vccd1 sky130_fd_sc_hd__fill_1
XFILLER_37_173 vssd1 vssd1 vccd1 vccd1 sky130_fd_sc_hd__fill_1
XANTENNA__2413__S _2419_/S vssd1 vssd1 vccd1 vccd1 sky130_fd_sc_hd__diode_2
XANTENNA_fanout405_X fanout405/X vssd1 vssd1 vccd1 vccd1 sky130_fd_sc_hd__diode_2
XANTENNA_fanout98_A _3735_/S vssd1 vssd1 vccd1 vccd1 sky130_fd_sc_hd__diode_2
XANTENNA__3161__B1 _2250_/S vssd1 vssd1 vccd1 vccd1 sky130_fd_sc_hd__diode_2
Xhold20 hold20/A vssd1 vssd1 vccd1 vccd1 hold20/X sky130_fd_sc_hd__dlygate4sd3_1
Xhold31 hold31/A vssd1 vssd1 vccd1 vccd1 hold31/X sky130_fd_sc_hd__dlygate4sd3_1
XFILLER_0_489 vccd1 vssd1 vccd1 vssd1 sky130_ef_sc_hd__decap_12
Xhold42 hold42/A vssd1 vssd1 vccd1 vccd1 hold42/X sky130_fd_sc_hd__dlygate4sd3_1
XANTENNA__4286__D _4352_/A vssd1 vssd1 vccd1 vccd1 sky130_fd_sc_hd__diode_2
Xhold64 hold64/A vssd1 vssd1 vccd1 vccd1 hold64/X sky130_fd_sc_hd__dlygate4sd3_1
Xhold53 hold53/A vssd1 vssd1 vccd1 vccd1 hold53/X sky130_fd_sc_hd__dlygate4sd3_1
Xhold86 hold86/A vssd1 vssd1 vccd1 vccd1 hold86/X sky130_fd_sc_hd__dlygate4sd3_1
Xhold97 hold97/A vssd1 vssd1 vccd1 vccd1 hold97/X sky130_fd_sc_hd__dlygate4sd3_1
XTAP_TAPCELL_ROW_46_606 vssd1 vccd1 sky130_fd_sc_hd__tapvpwrvgnd_1
Xhold75 hold75/A vssd1 vssd1 vccd1 vccd1 hold75/X sky130_fd_sc_hd__dlygate4sd3_1
XANTENNA__4075__S _4075_/S vssd1 vssd1 vccd1 vccd1 sky130_fd_sc_hd__diode_2
XTAP_TAPCELL_ROW_54_672 vssd1 vccd1 sky130_fd_sc_hd__tapvpwrvgnd_1
XANTENNA__4192__A2 _4212_/A2 vssd1 vssd1 vccd1 vccd1 sky130_fd_sc_hd__diode_2
XFILLER_6_79 vssd1 vssd1 vccd1 vccd1 sky130_fd_sc_hd__decap_4
X_3170_ _4570_/Q _4611_/Q vssd1 vssd1 vccd1 vccd1 _3498_/B sky130_fd_sc_hd__or2_1
XFILLER_81_249 vccd1 vssd1 vccd1 vssd1 sky130_ef_sc_hd__decap_12
XTAP_TAPCELL_ROW_80_907 vssd1 vccd1 sky130_fd_sc_hd__tapvpwrvgnd_1
XFILLER_19_184 vccd1 vssd1 vccd1 vssd1 sky130_ef_sc_hd__decap_12
XTAP_TAPCELL_ROW_17_341 vssd1 vccd1 sky130_fd_sc_hd__tapvpwrvgnd_1
X_2954_ _2954_/A _2954_/B vssd1 vssd1 vccd1 vccd1 _2954_/Y sky130_fd_sc_hd__xnor2_1
X_2885_ _2861_/B _2862_/Y _2917_/B _2884_/X vssd1 vssd1 vccd1 vccd1 _2899_/A sky130_fd_sc_hd__a211o_1
XPHY_EDGE_ROW_6_Right_6 vssd1 vssd1 vccd1 vccd1 sky130_fd_sc_hd__decap_3
X_4624_ _4624_/CLK _4624_/D fanout407/X vssd1 vssd1 vccd1 vccd1 _4624_/Q sky130_fd_sc_hd__dfrtp_1
X_4555_ _4597_/CLK _4555_/D fanout412/X vssd1 vssd1 vccd1 vccd1 _4555_/Q sky130_fd_sc_hd__dfrtp_2
X_3506_ _3164_/Y _3169_/Y _3496_/Y _3168_/B _3166_/A vssd1 vssd1 vccd1 vccd1 _3507_/B
+ sky130_fd_sc_hd__o311ai_1
XANTENNA_fanout100_A _3542_/X vssd1 vssd1 vccd1 vccd1 sky130_fd_sc_hd__diode_2
X_4486_ _4820_/CLK _4486_/D _2229_/B vssd1 vssd1 vccd1 vccd1 hold3/A sky130_fd_sc_hd__dfrtp_1
X_3437_ _3437_/A _3437_/B vssd1 vssd1 vccd1 vccd1 _3437_/Y sky130_fd_sc_hd__xnor2_1
X_3368_ _4547_/Q _3396_/A2 _3366_/X _3367_/X vssd1 vssd1 vccd1 vccd1 _4547_/D sky130_fd_sc_hd__a22o_1
XFILLER_66_29 vssd1 vssd1 vccd1 vccd1 sky130_fd_sc_hd__fill_2
X_2319_ _4017_/D _2335_/B _2335_/C vssd1 vssd1 vccd1 vccd1 _2319_/X sky130_fd_sc_hd__and3_1
X_3299_ _3301_/A _3301_/C vssd1 vssd1 vccd1 vccd1 _3469_/A sky130_fd_sc_hd__or2_1
XTAP_TAPCELL_ROW_68_797 vssd1 vccd1 sky130_fd_sc_hd__tapvpwrvgnd_1
XANTENNA__2408__S _2420_/S vssd1 vssd1 vccd1 vccd1 sky130_fd_sc_hd__diode_2
XANTENNA_fanout355_X _4377_/B1 vssd1 vssd1 vccd1 vccd1 sky130_fd_sc_hd__diode_2
XFILLER_53_441 vssd1 vssd1 vccd1 vccd1 sky130_fd_sc_hd__decap_6
XFILLER_80_271 vssd1 vssd1 vccd1 vccd1 sky130_fd_sc_hd__fill_2
XFILLER_40_135 vssd1 vssd1 vccd1 vccd1 sky130_fd_sc_hd__decap_4
XFILLER_15_99 vssd1 vssd1 vccd1 vccd1 sky130_fd_sc_hd__fill_1
XTAP_TAPCELL_ROW_23_399 vssd1 vccd1 sky130_fd_sc_hd__tapvpwrvgnd_1
Xoutput43 hold88/A vssd1 vssd1 vccd1 vccd1 m_axis_tdata[15] sky130_fd_sc_hd__buf_2
Xoutput65 hold68/A vssd1 vssd1 vccd1 vccd1 m_axis_tdata[35] sky130_fd_sc_hd__buf_2
Xoutput54 hold8/A vssd1 vssd1 vccd1 vccd1 m_axis_tdata[25] sky130_fd_sc_hd__buf_2
Xoutput76 hold16/A vssd1 vssd1 vccd1 vccd1 m_axis_tdata[9] sky130_fd_sc_hd__buf_2
XFILLER_0_253 vssd1 vssd1 vccd1 vccd1 sky130_fd_sc_hd__decap_4
XANTENNA_input30_A s_axis_tdata[5] vssd1 vssd1 vccd1 vccd1 sky130_fd_sc_hd__diode_2
XFILLER_0_297 vssd1 vssd1 vccd1 vccd1 sky130_fd_sc_hd__decap_8
XTAP_TAPCELL_ROW_59_720 vssd1 vccd1 sky130_fd_sc_hd__tapvpwrvgnd_1
XFILLER_63_227 vssd1 vssd1 vccd1 vccd1 sky130_fd_sc_hd__decap_4
XFILLER_63_238 vccd1 vssd1 vccd1 vssd1 sky130_ef_sc_hd__decap_12
XFILLER_16_165 vccd1 vssd1 vccd1 vssd1 sky130_ef_sc_hd__decap_12
XTAP_TAPCELL_ROW_14_311 vssd1 vccd1 sky130_fd_sc_hd__tapvpwrvgnd_1
XPHY_EDGE_ROW_59_Right_59 vssd1 vssd1 vccd1 vccd1 sky130_fd_sc_hd__decap_3
XFILLER_8_331 vccd1 vssd1 vccd1 vssd1 sky130_ef_sc_hd__decap_12
X_2670_ _4741_/Q _4711_/Q vssd1 vssd1 vccd1 vccd1 _2672_/A sky130_fd_sc_hd__and2_1
XANTENNA__4165__A2 _4176_/A2 vssd1 vssd1 vccd1 vccd1 sky130_fd_sc_hd__diode_2
XANTENNA__3373__B1 _3541_/B1 vssd1 vssd1 vccd1 vccd1 sky130_fd_sc_hd__diode_2
XANTENNA__3912__A2 _4173_/A2 vssd1 vssd1 vccd1 vccd1 sky130_fd_sc_hd__diode_2
X_4340_ _4340_/A _4344_/B vssd1 vssd1 vccd1 vccd1 _4340_/Y sky130_fd_sc_hd__nor2_1
X_4271_ _4336_/A _4279_/A2 _4280_/B2 vssd1 vssd1 vccd1 vccd1 _4271_/Y sky130_fd_sc_hd__o21ai_1
XFILLER_79_360 vssd1 vssd1 vccd1 vccd1 sky130_fd_sc_hd__decap_4
X_3222_ _4555_/Q _4596_/Q vssd1 vssd1 vccd1 vccd1 _3225_/A sky130_fd_sc_hd__and2_1
X_3153_ _3153_/A _3153_/B vssd1 vssd1 vccd1 vccd1 _3155_/B sky130_fd_sc_hd__xnor2_1
XFILLER_79_393 vssd1 vssd1 vccd1 vccd1 sky130_fd_sc_hd__decap_8
XPHY_EDGE_ROW_68_Right_68 vssd1 vssd1 vccd1 vccd1 sky130_fd_sc_hd__decap_3
X_3084_ _3085_/B _3085_/C _3151_/A vssd1 vssd1 vccd1 vccd1 _3087_/B sky130_fd_sc_hd__a21o_1
XFILLER_39_279 vssd1 vssd1 vccd1 vccd1 sky130_fd_sc_hd__fill_1
XFILLER_54_205 vccd1 vssd1 vccd1 vssd1 sky130_ef_sc_hd__decap_12
XTAP_TAPCELL_ROW_65_778 vssd1 vccd1 sky130_fd_sc_hd__tapvpwrvgnd_1
XFILLER_62_271 vssd1 vssd1 vccd1 vccd1 sky130_fd_sc_hd__fill_1
XPHY_EDGE_ROW_77_Right_77 vssd1 vssd1 vccd1 vccd1 sky130_fd_sc_hd__decap_3
X_3986_ _3985_/D _4022_/A2 _3995_/B2 vssd1 vssd1 vccd1 vccd1 _3986_/Y sky130_fd_sc_hd__o21ai_1
X_2937_ _3023_/A _4749_/Q vssd1 vssd1 vccd1 vccd1 _2938_/B sky130_fd_sc_hd__nor2_1
XANTENNA_fanout315_A _4797_/Q vssd1 vssd1 vccd1 vccd1 sky130_fd_sc_hd__diode_2
X_2868_ _4702_/Q _2869_/B vssd1 vssd1 vccd1 vccd1 _2868_/Y sky130_fd_sc_hd__nor2_1
X_4607_ _4609_/CLK _4607_/D fanout427/X vssd1 vssd1 vccd1 vccd1 _4607_/Q sky130_fd_sc_hd__dfrtp_1
XTAP_TAPCELL_ROW_20_369 vssd1 vccd1 sky130_fd_sc_hd__tapvpwrvgnd_1
X_2799_ _2869_/B _4700_/Q vssd1 vssd1 vccd1 vccd1 _2799_/X sky130_fd_sc_hd__and2_1
X_4538_ _4647_/CLK _4538_/D fanout428/X vssd1 vssd1 vccd1 vccd1 _4538_/Q sky130_fd_sc_hd__dfrtp_1
XANTENNA_fanout103_X _3425_/A2 vssd1 vssd1 vccd1 vccd1 sky130_fd_sc_hd__diode_2
X_4469_ _4587_/CLK _4469_/D fanout415/X vssd1 vssd1 vccd1 vccd1 hold24/A sky130_fd_sc_hd__dfrtp_1
XPHY_EDGE_ROW_86_Right_86 vssd1 vssd1 vccd1 vccd1 sky130_fd_sc_hd__decap_3
XFILLER_5_301 vssd1 vssd1 vccd1 vccd1 sky130_fd_sc_hd__fill_1
XFILLER_3_47 vssd1 vssd1 vccd1 vccd1 sky130_fd_sc_hd__decap_8
XFILLER_76_385 vccd1 vssd1 vccd1 vssd1 sky130_ef_sc_hd__decap_12
XFILLER_17_430 vccd1 vssd1 vccd1 vssd1 sky130_ef_sc_hd__decap_12
XANTENNA__4083__A1 _4083_/A1 vssd1 vssd1 vccd1 vccd1 sky130_fd_sc_hd__diode_2
XTAP_TAPCELL_ROW_62_748 vssd1 vccd1 sky130_fd_sc_hd__tapvpwrvgnd_1
XFILLER_32_433 vccd1 vssd1 vccd1 vssd1 sky130_ef_sc_hd__decap_12
X_3840_ hold219/X _3848_/A2 _3839_/Y vssd1 vssd1 vccd1 vccd1 _4638_/D sky130_fd_sc_hd__a21o_1
X_3771_ _3784_/A1 _3543_/B _4611_/Q vssd1 vssd1 vccd1 vccd1 _3771_/Y sky130_fd_sc_hd__a21oi_1
X_2722_ _2722_/A _2722_/B _2722_/C vssd1 vssd1 vccd1 vccd1 _2723_/B sky130_fd_sc_hd__nor3_1
X_2653_ _2653_/A _2653_/B vssd1 vssd1 vccd1 vccd1 _3821_/B sky130_fd_sc_hd__xor2_1
X_2584_ _2584_/A _2584_/B vssd1 vssd1 vccd1 vccd1 _2585_/B sky130_fd_sc_hd__nand2_1
X_4323_ _4339_/A0 _4343_/A1 _4323_/S vssd1 vssd1 vccd1 vccd1 _4323_/X sky130_fd_sc_hd__mux2_1
Xfanout107 _2873_/Y vssd1 vssd1 vccd1 vccd1 _3074_/C sky130_fd_sc_hd__buf_2
Xfanout118 _2930_/A2 vssd1 vssd1 vccd1 vccd1 _2985_/A2 sky130_fd_sc_hd__clkbuf_2
Xfanout129 _2274_/Y vssd1 vssd1 vccd1 vccd1 _4376_/A2 sky130_fd_sc_hd__clkbuf_2
XFILLER_59_319 vssd1 vssd1 vccd1 vccd1 sky130_fd_sc_hd__decap_4
X_4254_ _4286_/A_N _4282_/B _4270_/C _4320_/A vssd1 vssd1 vccd1 vccd1 _4254_/X sky130_fd_sc_hd__and4b_1
XFILLER_67_352 vssd1 vssd1 vccd1 vccd1 sky130_fd_sc_hd__fill_1
X_4185_ _4184_/Y _4183_/X _4182_/X hold177/X _4192_/B1 vssd1 vssd1 vccd1 vccd1 _4738_/D
+ sky130_fd_sc_hd__o32a_1
X_3205_ _4559_/Q _4600_/Q vssd1 vssd1 vccd1 vccd1 _3207_/A sky130_fd_sc_hd__and2_1
X_3136_ _3112_/C _3111_/Y _3126_/B _3126_/C _3112_/A vssd1 vssd1 vccd1 vccd1 _3136_/Y
+ sky130_fd_sc_hd__a221oi_2
XTAP_TAPCELL_ROW_78_892 vssd1 vccd1 sky130_fd_sc_hd__tapvpwrvgnd_1
X_3067_ _3067_/A _3067_/B vssd1 vssd1 vccd1 vccd1 _3067_/Y sky130_fd_sc_hd__nor2_1
XFILLER_82_377 vssd1 vssd1 vccd1 vccd1 sky130_fd_sc_hd__decap_8
XANTENNA_fanout265_A _4211_/B vssd1 vssd1 vccd1 vccd1 sky130_fd_sc_hd__diode_2
XTAP_TAPCELL_ROW_25_417 vssd1 vccd1 sky130_fd_sc_hd__tapvpwrvgnd_1
XFILLER_50_230 vssd1 vssd1 vccd1 vccd1 sky130_fd_sc_hd__fill_1
XFILLER_23_477 vssd1 vssd1 vccd1 vccd1 sky130_fd_sc_hd__fill_1
XFILLER_10_138 vssd1 vssd1 vccd1 vccd1 sky130_fd_sc_hd__fill_2
XANTENNA_fanout220_X _3971_/A1 vssd1 vssd1 vccd1 vccd1 sky130_fd_sc_hd__diode_2
X_3969_ _4037_/D _3873_/Y _3968_/X _4015_/B2 vssd1 vssd1 vccd1 vccd1 _3969_/X sky130_fd_sc_hd__o211a_1
XTAP_TAPCELL_ROW_33_483 vssd1 vccd1 sky130_fd_sc_hd__tapvpwrvgnd_1
XFILLER_50_296 vccd1 vssd1 vccd1 vssd1 sky130_ef_sc_hd__decap_12
XANTENNA__4129__A2 _4173_/A2 vssd1 vssd1 vccd1 vccd1 sky130_fd_sc_hd__diode_2
XANTENNA__2421__S _2421_/S vssd1 vssd1 vccd1 vccd1 sky130_fd_sc_hd__diode_2
Xhold161 _4693_/Q vssd1 vssd1 vccd1 vccd1 hold161/X sky130_fd_sc_hd__dlygate4sd3_1
Xhold150 _4467_/Q vssd1 vssd1 vccd1 vccd1 hold150/X sky130_fd_sc_hd__dlygate4sd3_1
Xhold183 _4806_/Q vssd1 vssd1 vccd1 vccd1 hold183/X sky130_fd_sc_hd__dlygate4sd3_1
Xhold172 _4683_/Q vssd1 vssd1 vccd1 vccd1 hold172/X sky130_fd_sc_hd__dlygate4sd3_1
Xhold194 _4632_/Q vssd1 vssd1 vccd1 vccd1 hold194/X sky130_fd_sc_hd__dlygate4sd3_1
XANTENNA__2312__A1 _4071_/S vssd1 vssd1 vccd1 vccd1 sky130_fd_sc_hd__diode_2
XFILLER_58_352 vccd1 vssd1 vccd1 vssd1 sky130_ef_sc_hd__decap_12
XANTENNA__4294__D _4360_/A vssd1 vssd1 vccd1 vccd1 sky130_fd_sc_hd__diode_2
XFILLER_18_238 vssd1 vssd1 vccd1 vccd1 sky130_fd_sc_hd__decap_4
XFILLER_58_396 vssd1 vssd1 vccd1 vccd1 sky130_fd_sc_hd__fill_1
XANTENNA__4065__A1 _4064_/D vssd1 vssd1 vccd1 vccd1 sky130_fd_sc_hd__diode_2
XFILLER_14_433 vssd1 vssd1 vccd1 vccd1 sky130_fd_sc_hd__fill_1
XANTENNA__4083__S _4223_/C vssd1 vssd1 vccd1 vccd1 sky130_fd_sc_hd__diode_2
XFILLER_14_477 vssd1 vssd1 vccd1 vccd1 sky130_fd_sc_hd__decap_4
XFILLER_5_153 vssd1 vssd1 vccd1 vccd1 sky130_fd_sc_hd__fill_1
XFILLER_5_142 vssd1 vssd1 vccd1 vccd1 sky130_fd_sc_hd__fill_1
XFILLER_1_381 vssd1 vssd1 vccd1 vccd1 sky130_fd_sc_hd__decap_8
XTAP_TAPCELL_ROW_75_862 vssd1 vccd1 sky130_fd_sc_hd__tapvpwrvgnd_1
XFILLER_17_293 vccd1 vssd1 vccd1 vssd1 sky130_ef_sc_hd__decap_12
X_3823_ _3823_/A _3823_/B vssd1 vssd1 vccd1 vccd1 _3823_/Y sky130_fd_sc_hd__nor2_1
X_3754_ _3754_/A _3754_/B vssd1 vssd1 vccd1 vccd1 _3759_/C sky130_fd_sc_hd__or2_1
X_2705_ _2753_/B _2705_/B _2753_/D _2705_/D vssd1 vssd1 vccd1 vccd1 _2706_/B sky130_fd_sc_hd__nand4_1
X_3685_ _3685_/A _3685_/B vssd1 vssd1 vccd1 vccd1 _3727_/B sky130_fd_sc_hd__nand2_1
XANTENNA__4438__RESET_B fanout435/X vssd1 vssd1 vccd1 vccd1 sky130_fd_sc_hd__diode_2
X_2636_ _2636_/A _2636_/B vssd1 vssd1 vccd1 vccd1 _2637_/B sky130_fd_sc_hd__nor2_1
X_2567_ _4738_/Q _4708_/Q vssd1 vssd1 vccd1 vccd1 _2571_/A sky130_fd_sc_hd__and2_1
X_4306_ _4245_/D _4306_/B _4306_/C _4371_/A vssd1 vssd1 vccd1 vccd1 _4306_/X sky130_fd_sc_hd__and4b_1
X_2498_ _4720_/Q _4705_/Q vssd1 vssd1 vccd1 vccd1 _2528_/C sky130_fd_sc_hd__nand2_1
XFILLER_59_116 vssd1 vssd1 vccd1 vccd1 sky130_fd_sc_hd__decap_3
X_4237_ _4236_/Y _4235_/X _4234_/X _4751_/Q _4240_/B1 vssd1 vssd1 vccd1 vccd1 _4751_/D
+ sky130_fd_sc_hd__o32a_1
XANTENNA_fanout382_A fanout405/X vssd1 vssd1 vccd1 vccd1 sky130_fd_sc_hd__diode_2
XANTENNA__4295__A1 _4360_/A vssd1 vssd1 vccd1 vccd1 sky130_fd_sc_hd__diode_2
X_4168_ _4231_/D _4172_/B _4168_/C _4302_/D vssd1 vssd1 vccd1 vccd1 _4168_/X sky130_fd_sc_hd__and4b_1
XANTENNA_clkbuf_leaf_4_clk_A clkload0/A vssd1 vssd1 vccd1 vccd1 sky130_fd_sc_hd__diode_2
XTAP_TAPCELL_ROW_38_531 vssd1 vccd1 sky130_fd_sc_hd__tapvpwrvgnd_1
XFILLER_82_141 vssd1 vssd1 vccd1 vccd1 sky130_fd_sc_hd__fill_1
X_3119_ _3112_/C _3111_/Y _3112_/A vssd1 vssd1 vccd1 vccd1 _3119_/Y sky130_fd_sc_hd__a21oi_1
XANTENNA_fanout170_X _4083_/A1 vssd1 vssd1 vccd1 vccd1 sky130_fd_sc_hd__diode_2
XANTENNA__4047__A1 _4083_/A1 vssd1 vssd1 vccd1 vccd1 sky130_fd_sc_hd__diode_2
X_4099_ _4099_/A0 _4103_/A1 _4372_/A vssd1 vssd1 vccd1 vccd1 _4099_/X sky130_fd_sc_hd__mux2_1
XANTENNA__2416__S _2420_/S vssd1 vssd1 vccd1 vccd1 sky130_fd_sc_hd__diode_2
XFILLER_70_358 vssd1 vssd1 vccd1 vccd1 sky130_fd_sc_hd__decap_6
XANTENNA_fanout435_X fanout435/X vssd1 vssd1 vccd1 vccd1 sky130_fd_sc_hd__diode_2
XFILLER_11_436 vccd1 vssd1 vccd1 vssd1 sky130_ef_sc_hd__decap_12
XANTENNA_fanout83_X _3460_/A1 vssd1 vssd1 vccd1 vccd1 sky130_fd_sc_hd__diode_2
XFILLER_48_52 vssd1 vssd1 vccd1 vccd1 sky130_fd_sc_hd__fill_2
XFILLER_19_503 vssd1 vssd1 vccd1 vccd1 sky130_fd_sc_hd__fill_1
XFILLER_19_514 vssd1 vssd1 vccd1 vccd1 sky130_fd_sc_hd__fill_1
XFILLER_48_85 vssd1 vssd1 vccd1 vccd1 sky130_fd_sc_hd__fill_2
XFILLER_0_15 vccd1 vssd1 vccd1 vssd1 sky130_ef_sc_hd__decap_12
XFILLER_73_152 vssd1 vssd1 vccd1 vccd1 sky130_fd_sc_hd__decap_6
XANTENNA__4038__A1 _4037_/D vssd1 vssd1 vccd1 vccd1 sky130_fd_sc_hd__diode_2
XFILLER_46_355 vssd1 vssd1 vccd1 vccd1 sky130_fd_sc_hd__decap_6
XPHY_EDGE_ROW_14_Left_102 vssd1 vssd1 vccd1 vccd1 sky130_fd_sc_hd__decap_3
XFILLER_46_377 vccd1 vssd1 vccd1 vssd1 sky130_ef_sc_hd__decap_12
XTAP_TAPCELL_ROW_44_589 vssd1 vccd1 sky130_fd_sc_hd__tapvpwrvgnd_1
XFILLER_9_57 vssd1 vssd1 vccd1 vccd1 sky130_fd_sc_hd__decap_6
XFILLER_80_72 vccd1 vssd1 vccd1 vssd1 sky130_ef_sc_hd__decap_12
XANTENNA__4210__A1 _4210_/A1 vssd1 vssd1 vccd1 vccd1 sky130_fd_sc_hd__diode_2
XPHY_EDGE_ROW_23_Left_111 vssd1 vssd1 vccd1 vccd1 sky130_fd_sc_hd__decap_3
X_3470_ _3536_/A2 _3469_/X _3536_/B1 vssd1 vssd1 vccd1 vccd1 _3470_/X sky130_fd_sc_hd__a21o_1
XANTENNA__4199__D _4199_/D vssd1 vssd1 vccd1 vccd1 sky130_fd_sc_hd__diode_2
X_2421_ _4578_/Q hold39/A _2421_/S vssd1 vssd1 vccd1 vccd1 _2421_/X sky130_fd_sc_hd__mux2_1
X_2352_ hold48/X _2351_/X _2366_/S vssd1 vssd1 vccd1 vccd1 _4471_/D sky130_fd_sc_hd__mux2_1
XFILLER_69_447 vssd1 vssd1 vccd1 vccd1 sky130_fd_sc_hd__fill_1
X_2283_ _3981_/D _2338_/B vssd1 vssd1 vccd1 vccd1 _2283_/Y sky130_fd_sc_hd__nor2_1
X_4022_ _4021_/D _4022_/A2 _4138_/B1 vssd1 vssd1 vccd1 vccd1 _4022_/Y sky130_fd_sc_hd__o21ai_1
XPHY_EDGE_ROW_32_Left_120 vssd1 vssd1 vccd1 vccd1 sky130_fd_sc_hd__decap_3
XTAP_TAPCELL_ROW_35_501 vssd1 vccd1 sky130_fd_sc_hd__tapvpwrvgnd_1
XFILLER_52_358 vssd1 vssd1 vccd1 vccd1 sky130_fd_sc_hd__decap_6
X_4786_ _4819_/CLK _4786_/D fanout403/X vssd1 vssd1 vccd1 vccd1 _4786_/Q sky130_fd_sc_hd__dfrtp_1
X_3806_ _3572_/B _3806_/A2 _3805_/X vssd1 vssd1 vccd1 vccd1 _4621_/D sky130_fd_sc_hd__o21ai_1
XANTENNA_fanout228_A _4081_/A2 vssd1 vssd1 vccd1 vccd1 sky130_fd_sc_hd__diode_2
X_3737_ _4532_/Q _4641_/Q vssd1 vssd1 vccd1 vccd1 _3743_/C sky130_fd_sc_hd__and2_1
XFILLER_20_299 vssd1 vssd1 vccd1 vccd1 sky130_fd_sc_hd__decap_8
X_3668_ _4524_/Q _4633_/Q vssd1 vssd1 vccd1 vccd1 _3690_/C sky130_fd_sc_hd__and2_1
X_3599_ _4516_/Q _4625_/Q vssd1 vssd1 vccd1 vccd1 _3627_/A sky130_fd_sc_hd__and2_1
X_2619_ _2617_/A _2617_/B _2617_/C _2617_/D vssd1 vssd1 vccd1 vccd1 _2621_/A sky130_fd_sc_hd__a22o_1
XTAP_TAPCELL_ROW_7_248 vssd1 vccd1 sky130_fd_sc_hd__tapvpwrvgnd_1
XFILLER_87_277 vssd1 vssd1 vccd1 vccd1 sky130_fd_sc_hd__decap_3
XFILLER_85_39 vccd1 vssd1 vccd1 vssd1 sky130_ef_sc_hd__decap_12
XFILLER_75_406 vssd1 vssd1 vccd1 vccd1 sky130_fd_sc_hd__fill_1
XFILLER_28_355 vssd1 vssd1 vccd1 vccd1 sky130_fd_sc_hd__decap_8
XFILLER_43_314 vssd1 vssd1 vccd1 vccd1 sky130_fd_sc_hd__decap_8
XFILLER_55_185 vccd1 vssd1 vccd1 vssd1 sky130_ef_sc_hd__decap_12
XFILLER_43_358 vssd1 vssd1 vccd1 vccd1 sky130_fd_sc_hd__decap_8
XFILLER_34_65 vssd1 vssd1 vccd1 vccd1 sky130_fd_sc_hd__fill_2
XFILLER_34_76 vssd1 vssd1 vccd1 vccd1 sky130_fd_sc_hd__fill_2
XTAP_TAPCELL_ROW_41_559 vssd1 vccd1 sky130_fd_sc_hd__tapvpwrvgnd_1
XANTENNA__3703__B1 _3549_/A vssd1 vssd1 vccd1 vccd1 sky130_fd_sc_hd__diode_2
XFILLER_38_119 vssd1 vssd1 vccd1 vccd1 sky130_fd_sc_hd__fill_1
XANTENNA__4259__A1 _4324_/A vssd1 vssd1 vccd1 vccd1 sky130_fd_sc_hd__diode_2
Xfanout290 _4808_/Q vssd1 vssd1 vccd1 vccd1 _4001_/B sky130_fd_sc_hd__buf_2
XTAP_TAPCELL_ROW_49_626 vssd1 vccd1 sky130_fd_sc_hd__tapvpwrvgnd_1
XFILLER_74_494 vssd1 vssd1 vccd1 vccd1 sky130_fd_sc_hd__fill_1
X_2970_ _2971_/B _2971_/A vssd1 vssd1 vccd1 vccd1 _2970_/Y sky130_fd_sc_hd__nor2_1
XFILLER_61_199 vssd1 vssd1 vccd1 vccd1 sky130_fd_sc_hd__decap_4
X_4640_ _4640_/CLK _4640_/D fanout427/X vssd1 vssd1 vccd1 vccd1 _4640_/Q sky130_fd_sc_hd__dfrtp_1
X_4571_ _4575_/CLK _4571_/D fanout439/X vssd1 vssd1 vccd1 vccd1 _4571_/Q sky130_fd_sc_hd__dfrtp_2
XTAP_TAPCELL_ROW_12_294 vssd1 vccd1 sky130_fd_sc_hd__tapvpwrvgnd_1
X_3522_ _4575_/Q _3522_/A2 _3521_/X _3503_/X vssd1 vssd1 vccd1 vccd1 _4575_/D sky130_fd_sc_hd__a22o_1
X_3453_ _4562_/Q _4603_/Q _3203_/B _3451_/Y vssd1 vssd1 vccd1 vccd1 _3453_/Y sky130_fd_sc_hd__o211ai_1
X_2404_ hold59/X _2403_/X _2420_/S vssd1 vssd1 vccd1 vccd1 _4497_/D sky130_fd_sc_hd__mux2_1
X_3384_ _4591_/Q _3384_/A2 _3395_/B1 _3561_/C vssd1 vssd1 vccd1 vccd1 _3384_/X sky130_fd_sc_hd__o211a_1
XFILLER_69_277 vssd1 vssd1 vccd1 vccd1 sky130_fd_sc_hd__decap_3
XTAP_TAPCELL_ROW_4_229 vssd1 vccd1 sky130_fd_sc_hd__tapvpwrvgnd_1
X_2335_ _4033_/D _2335_/B _2335_/C vssd1 vssd1 vccd1 vccd1 _2335_/X sky130_fd_sc_hd__and3_1
XFILLER_29_108 vssd1 vssd1 vccd1 vccd1 sky130_fd_sc_hd__decap_4
XFILLER_57_417 vssd1 vssd1 vccd1 vccd1 sky130_fd_sc_hd__decap_8
X_2266_ hold50/X _4574_/Q _2271_/S vssd1 vssd1 vccd1 vccd1 _4445_/D sky130_fd_sc_hd__mux2_1
XFILLER_84_247 vssd1 vssd1 vccd1 vccd1 sky130_fd_sc_hd__decap_4
X_4005_ _4064_/C _4037_/B _4037_/C _4005_/D vssd1 vssd1 vccd1 vccd1 _4005_/X sky130_fd_sc_hd__and4b_1
XTAP_TAPCELL_ROW_83_938 vssd1 vccd1 sky130_fd_sc_hd__tapvpwrvgnd_1
XANTENNA_fanout345_A _4316_/A vssd1 vssd1 vccd1 vccd1 sky130_fd_sc_hd__diode_2
XANTENNA__4186__A0 _4214_/A0 vssd1 vssd1 vccd1 vccd1 sky130_fd_sc_hd__diode_2
X_4769_ _4818_/CLK _4769_/D fanout397/X vssd1 vssd1 vccd1 vccd1 _4769_/Q sky130_fd_sc_hd__dfrtp_1
XANTENNA_fanout300_X _4037_/D vssd1 vssd1 vccd1 vccd1 sky130_fd_sc_hd__diode_2
XFILLER_0_446 vssd1 vssd1 vccd1 vccd1 sky130_fd_sc_hd__fill_2
Xhold21 hold21/A vssd1 vssd1 vccd1 vccd1 hold21/X sky130_fd_sc_hd__dlygate4sd3_1
XFILLER_29_32 vssd1 vssd1 vccd1 vccd1 sky130_fd_sc_hd__fill_1
Xhold10 hold10/A vssd1 vssd1 vccd1 vccd1 hold10/X sky130_fd_sc_hd__dlygate4sd3_1
Xhold32 hold32/A vssd1 vssd1 vccd1 vccd1 hold32/X sky130_fd_sc_hd__dlygate4sd3_1
XFILLER_48_417 vssd1 vssd1 vccd1 vccd1 sky130_fd_sc_hd__decap_3
Xhold65 hold65/A vssd1 vssd1 vccd1 vccd1 hold65/X sky130_fd_sc_hd__dlygate4sd3_1
Xhold54 hold54/A vssd1 vssd1 vccd1 vccd1 hold54/X sky130_fd_sc_hd__dlygate4sd3_1
XANTENNA__3449__C1 _3923_/A vssd1 vssd1 vccd1 vccd1 sky130_fd_sc_hd__diode_2
Xhold43 hold43/A vssd1 vssd1 vccd1 vccd1 hold43/X sky130_fd_sc_hd__dlygate4sd3_1
XFILLER_75_247 vccd1 vssd1 vccd1 vssd1 sky130_ef_sc_hd__decap_12
Xhold76 hold76/A vssd1 vssd1 vccd1 vccd1 hold76/X sky130_fd_sc_hd__dlygate4sd3_1
Xhold87 hold87/A vssd1 vssd1 vccd1 vccd1 hold87/X sky130_fd_sc_hd__dlygate4sd3_1
Xhold98 hold98/A vssd1 vssd1 vccd1 vccd1 hold98/X sky130_fd_sc_hd__dlygate4sd3_1
XTAP_TAPCELL_ROW_46_607 vssd1 vccd1 sky130_fd_sc_hd__tapvpwrvgnd_1
XFILLER_28_174 vssd1 vssd1 vccd1 vccd1 sky130_fd_sc_hd__fill_1
XFILLER_71_431 vssd1 vssd1 vccd1 vccd1 sky130_fd_sc_hd__fill_2
XTAP_TAPCELL_ROW_54_673 vssd1 vccd1 sky130_fd_sc_hd__tapvpwrvgnd_1
XANTENNA__4091__S _4231_/C vssd1 vssd1 vccd1 vccd1 sky130_fd_sc_hd__diode_2
XPHY_EDGE_ROW_7_Left_95 vssd1 vssd1 vccd1 vccd1 sky130_fd_sc_hd__decap_3
XANTENNA__4104__B _4104_/B vssd1 vssd1 vccd1 vccd1 sky130_fd_sc_hd__diode_2
XANTENNA__2727__B2 _3870_/B1 vssd1 vssd1 vccd1 vccd1 sky130_fd_sc_hd__diode_2
XANTENNA__3924__B1 _4411_/S vssd1 vssd1 vccd1 vccd1 sky130_fd_sc_hd__diode_2
XFILLER_39_439 vssd1 vssd1 vccd1 vccd1 sky130_fd_sc_hd__decap_8
XFILLER_66_247 vssd1 vssd1 vccd1 vccd1 sky130_fd_sc_hd__fill_2
XANTENNA__3455__A2 _3504_/A2 vssd1 vssd1 vccd1 vccd1 sky130_fd_sc_hd__diode_2
XTAP_TAPCELL_ROW_80_908 vssd1 vccd1 sky130_fd_sc_hd__tapvpwrvgnd_1
XTAP_TAPCELL_ROW_17_342 vssd1 vccd1 sky130_fd_sc_hd__tapvpwrvgnd_1
XANTENNA_clkbuf_leaf_44_clk_A clkload2/A vssd1 vssd1 vccd1 vccd1 sky130_fd_sc_hd__diode_2
X_2953_ _2953_/A _2953_/B vssd1 vssd1 vccd1 vccd1 _2954_/B sky130_fd_sc_hd__xor2_1
XFILLER_15_380 vccd1 vssd1 vccd1 vssd1 sky130_ef_sc_hd__decap_12
XFILLER_22_317 vssd1 vssd1 vccd1 vccd1 sky130_fd_sc_hd__decap_4
XFILLER_22_328 vccd1 vssd1 vccd1 vssd1 sky130_ef_sc_hd__decap_12
X_2884_ _2917_/A _2877_/X _2882_/Y vssd1 vssd1 vccd1 vccd1 _2884_/X sky130_fd_sc_hd__o21a_1
X_4623_ _4624_/CLK _4623_/D fanout407/X vssd1 vssd1 vccd1 vccd1 _4623_/Q sky130_fd_sc_hd__dfrtp_1
X_4554_ _4597_/CLK _4554_/D fanout413/X vssd1 vssd1 vccd1 vccd1 _4554_/Q sky130_fd_sc_hd__dfrtp_2
X_3505_ _3166_/A _3498_/Y _3168_/B vssd1 vssd1 vccd1 vccd1 _3505_/Y sky130_fd_sc_hd__a21oi_1
X_4485_ _4820_/CLK _4485_/D _2229_/B vssd1 vssd1 vccd1 vccd1 hold11/A sky130_fd_sc_hd__dfrtp_1
X_3436_ _3432_/A _3432_/B _3207_/A vssd1 vssd1 vccd1 vccd1 _3437_/B sky130_fd_sc_hd__a21oi_1
XFILLER_85_501 vssd1 vssd1 vccd1 vccd1 sky130_fd_sc_hd__decap_3
X_3367_ _4588_/Q _3384_/A2 _3541_/B1 _3367_/C1 vssd1 vssd1 vccd1 vccd1 _3367_/X sky130_fd_sc_hd__o211a_1
X_2318_ _2341_/A0 _2341_/A1 _4021_/D vssd1 vssd1 vccd1 vccd1 _2318_/X sky130_fd_sc_hd__mux2_1
X_3298_ _4565_/Q _4606_/Q vssd1 vssd1 vccd1 vccd1 _3463_/B sky130_fd_sc_hd__xnor2_1
XTAP_TAPCELL_ROW_68_798 vssd1 vccd1 sky130_fd_sc_hd__tapvpwrvgnd_1
X_2249_ hold10/X _4557_/Q _2249_/S vssd1 vssd1 vccd1 vccd1 _4428_/D sky130_fd_sc_hd__mux2_1
XFILLER_82_29 vccd1 vssd1 vccd1 vssd1 sky130_ef_sc_hd__decap_12
XANTENNA_fanout250_X _4328_/C vssd1 vssd1 vccd1 vccd1 sky130_fd_sc_hd__diode_2
XANTENNA_fanout348_X _4316_/A vssd1 vssd1 vccd1 vccd1 sky130_fd_sc_hd__diode_2
XFILLER_13_339 vssd1 vssd1 vccd1 vccd1 sky130_fd_sc_hd__decap_8
XANTENNA__2424__S _2424_/S vssd1 vssd1 vccd1 vccd1 sky130_fd_sc_hd__diode_2
XANTENNA__4159__A0 _4171_/A0 vssd1 vssd1 vccd1 vccd1 sky130_fd_sc_hd__diode_2
XFILLER_5_505 vssd1 vssd1 vccd1 vccd1 sky130_fd_sc_hd__decap_8
Xoutput66 hold69/A vssd1 vssd1 vccd1 vccd1 m_axis_tdata[36] sky130_fd_sc_hd__buf_2
Xoutput55 hold49/A vssd1 vssd1 vccd1 vccd1 m_axis_tdata[26] sky130_fd_sc_hd__buf_2
Xoutput44 hold11/A vssd1 vssd1 vccd1 vccd1 m_axis_tdata[16] sky130_fd_sc_hd__buf_2
Xoutput77 _2226_/X vssd1 vssd1 vccd1 vccd1 m_axis_tvalid sky130_fd_sc_hd__buf_2
XTAP_TAPCELL_ROW_59_721 vssd1 vccd1 sky130_fd_sc_hd__tapvpwrvgnd_1
XANTENNA_input23_A s_axis_tdata[28] vssd1 vssd1 vccd1 vccd1 sky130_fd_sc_hd__diode_2
XFILLER_56_41 vssd1 vssd1 vccd1 vccd1 sky130_fd_sc_hd__fill_1
XFILLER_16_122 vssd1 vssd1 vccd1 vccd1 sky130_fd_sc_hd__decap_4
XFILLER_56_85 vssd1 vssd1 vccd1 vccd1 sky130_fd_sc_hd__fill_1
XTAP_TAPCELL_ROW_14_312 vssd1 vccd1 sky130_fd_sc_hd__tapvpwrvgnd_1
XANTENNA__4398__A0 _4001_/C vssd1 vssd1 vccd1 vccd1 sky130_fd_sc_hd__diode_2
XFILLER_16_177 vssd1 vssd1 vccd1 vccd1 sky130_fd_sc_hd__fill_2
XFILLER_72_95 vssd1 vssd1 vccd1 vccd1 sky130_fd_sc_hd__decap_6
XANTENNA__2334__S _4037_/D vssd1 vssd1 vccd1 vccd1 sky130_fd_sc_hd__diode_2
XFILLER_8_365 vssd1 vssd1 vccd1 vccd1 sky130_fd_sc_hd__decap_3
X_4270_ _4286_/A_N _4282_/B _4270_/C _4336_/A vssd1 vssd1 vccd1 vccd1 _4270_/X sky130_fd_sc_hd__and4b_1
XFILLER_86_309 vssd1 vssd1 vccd1 vccd1 sky130_fd_sc_hd__fill_2
X_3221_ _3221_/A _3221_/B vssd1 vssd1 vccd1 vccd1 _3226_/B sky130_fd_sc_hd__nor2_1
X_3152_ _3153_/A _3153_/B vssd1 vssd1 vccd1 vccd1 _3152_/Y sky130_fd_sc_hd__nand2_1
XFILLER_39_225 vccd1 vssd1 vccd1 vssd1 sky130_ef_sc_hd__decap_12
X_3083_ _2871_/C _2873_/A _3044_/Y vssd1 vssd1 vccd1 vccd1 _3085_/C sky130_fd_sc_hd__a21o_1
XFILLER_54_217 vssd1 vssd1 vccd1 vccd1 sky130_fd_sc_hd__decap_3
XANTENNA__4009__B _4037_/B vssd1 vssd1 vccd1 vccd1 sky130_fd_sc_hd__diode_2
XANTENNA__4389__A0 _4223_/C vssd1 vssd1 vccd1 vccd1 sky130_fd_sc_hd__diode_2
XFILLER_62_283 vccd1 vssd1 vccd1 vssd1 sky130_ef_sc_hd__decap_12
X_3985_ _3976_/D _4001_/B _4033_/C _3985_/D vssd1 vssd1 vccd1 vccd1 _3985_/X sky130_fd_sc_hd__and4b_1
X_2936_ _3023_/A _4749_/Q vssd1 vssd1 vccd1 vccd1 _2938_/A sky130_fd_sc_hd__and2_1
XFILLER_10_309 vssd1 vssd1 vccd1 vccd1 sky130_fd_sc_hd__decap_6
X_2867_ _4702_/Q _2869_/B vssd1 vssd1 vccd1 vccd1 _2871_/C sky130_fd_sc_hd__nand2_2
X_4606_ _4609_/CLK _4606_/D fanout427/X vssd1 vssd1 vccd1 vccd1 _4606_/Q sky130_fd_sc_hd__dfrtp_1
XANTENNA_fanout308_A _4360_/A vssd1 vssd1 vccd1 vccd1 sky130_fd_sc_hd__diode_2
X_2798_ _2795_/A _2795_/B _2792_/Y vssd1 vssd1 vccd1 vccd1 _2816_/A sky130_fd_sc_hd__o21bai_1
X_4537_ _4647_/CLK _4537_/D fanout428/X vssd1 vssd1 vccd1 vccd1 _4537_/Q sky130_fd_sc_hd__dfrtp_1
X_4468_ _4686_/CLK _4468_/D fanout384/X vssd1 vssd1 vccd1 vccd1 _4468_/Q sky130_fd_sc_hd__dfrtp_4
XANTENNA__4468__Q _4468_/Q vssd1 vssd1 vccd1 vccd1 sky130_fd_sc_hd__diode_2
X_3419_ _4597_/Q _3424_/A2 _3541_/B1 _3613_/C vssd1 vssd1 vccd1 vccd1 _3419_/X sky130_fd_sc_hd__o211a_1
X_4399_ _4001_/B input15/X _4402_/S vssd1 vssd1 vccd1 vccd1 _4808_/D sky130_fd_sc_hd__mux2_1
XFILLER_85_331 vssd1 vssd1 vccd1 vccd1 sky130_fd_sc_hd__decap_4
XANTENNA__2419__S _2419_/S vssd1 vssd1 vccd1 vccd1 sky130_fd_sc_hd__diode_2
XTAP_TAPCELL_ROW_28_437 vssd1 vccd1 sky130_fd_sc_hd__tapvpwrvgnd_1
XFILLER_60_209 vccd1 vssd1 vccd1 vssd1 sky130_ef_sc_hd__decap_12
XFILLER_26_475 vssd1 vssd1 vccd1 vccd1 sky130_fd_sc_hd__fill_1
XFILLER_53_272 vssd1 vssd1 vccd1 vccd1 sky130_fd_sc_hd__decap_8
XFILLER_41_445 vssd1 vssd1 vccd1 vccd1 sky130_fd_sc_hd__decap_3
XANTENNA__4156__A_N _4239_/D vssd1 vssd1 vccd1 vccd1 sky130_fd_sc_hd__diode_2
XFILLER_5_335 vssd1 vssd1 vccd1 vccd1 sky130_fd_sc_hd__fill_1
XPHY_EDGE_ROW_79_Left_167 vssd1 vssd1 vccd1 vccd1 sky130_fd_sc_hd__decap_3
XANTENNA__4556__RESET_B fanout423/X vssd1 vssd1 vccd1 vccd1 sky130_fd_sc_hd__diode_2
XFILLER_76_397 vssd1 vssd1 vccd1 vccd1 sky130_fd_sc_hd__decap_6
XFILLER_17_442 vssd1 vssd1 vccd1 vccd1 sky130_fd_sc_hd__decap_6
XTAP_TAPCELL_ROW_62_749 vssd1 vccd1 sky130_fd_sc_hd__tapvpwrvgnd_1
XFILLER_32_445 vccd1 vssd1 vccd1 vssd1 sky130_ef_sc_hd__decap_12
X_3770_ _4610_/Q _3792_/A2 _3769_/X vssd1 vssd1 vccd1 vccd1 _4610_/D sky130_fd_sc_hd__o21ba_1
X_2721_ _2674_/A _2674_/B _2722_/B _2722_/C _2669_/B vssd1 vssd1 vccd1 vccd1 _2723_/A
+ sky130_fd_sc_hd__o221a_1
XFILLER_66_3 vssd1 vssd1 vccd1 vccd1 sky130_fd_sc_hd__fill_1
X_2652_ _2653_/A _2653_/B vssd1 vssd1 vccd1 vccd1 _2690_/B sky130_fd_sc_hd__nand2_1
X_2583_ _2584_/B _2584_/A vssd1 vssd1 vccd1 vccd1 _2583_/Y sky130_fd_sc_hd__nor2_1
X_4322_ _4321_/Y _4320_/X _4319_/X hold209/X _4338_/A2 vssd1 vssd1 vccd1 vccd1 _4773_/D
+ sky130_fd_sc_hd__o32a_1
Xfanout108 _2873_/Y vssd1 vssd1 vccd1 vccd1 _3144_/A sky130_fd_sc_hd__clkbuf_2
Xfanout119 _2930_/A2 vssd1 vssd1 vccd1 vccd1 _3157_/A2 sky130_fd_sc_hd__buf_2
X_4253_ _4281_/A0 _4281_/A1 _4253_/S vssd1 vssd1 vccd1 vccd1 _4253_/X sky130_fd_sc_hd__mux2_1
X_3204_ _4560_/Q _4601_/Q vssd1 vssd1 vccd1 vccd1 _3437_/A sky130_fd_sc_hd__xor2_1
XFILLER_86_139 vssd1 vssd1 vccd1 vccd1 sky130_fd_sc_hd__fill_1
X_4184_ _4313_/S _4212_/A2 _4192_/B1 vssd1 vssd1 vccd1 vccd1 _4184_/Y sky130_fd_sc_hd__o21ai_1
X_3135_ _3135_/A _3135_/B vssd1 vssd1 vccd1 vccd1 _3135_/Y sky130_fd_sc_hd__xnor2_1
XANTENNA__4029__A_N _4104_/C vssd1 vssd1 vccd1 vccd1 sky130_fd_sc_hd__diode_2
XFILLER_82_345 vccd1 vssd1 vccd1 vssd1 sky130_ef_sc_hd__decap_12
XTAP_TAPCELL_ROW_78_893 vssd1 vccd1 sky130_fd_sc_hd__tapvpwrvgnd_1
X_3066_ _3066_/A _3066_/B vssd1 vssd1 vccd1 vccd1 _3067_/B sky130_fd_sc_hd__xnor2_1
XANTENNA_fanout160_A _4338_/A2 vssd1 vssd1 vccd1 vccd1 sky130_fd_sc_hd__diode_2
XTAP_TAPCELL_ROW_25_418 vssd1 vccd1 sky130_fd_sc_hd__tapvpwrvgnd_1
X_3968_ _4037_/D _3974_/A1 _4033_/D _3899_/Y vssd1 vssd1 vccd1 vccd1 _3968_/X sky130_fd_sc_hd__o2bb2a_1
XFILLER_50_253 vccd1 vssd1 vccd1 vssd1 sky130_ef_sc_hd__decap_12
XFILLER_50_275 vssd1 vssd1 vccd1 vccd1 sky130_fd_sc_hd__decap_3
X_2919_ _2872_/A _2868_/Y _2871_/C vssd1 vssd1 vccd1 vccd1 _2919_/X sky130_fd_sc_hd__o21a_1
XTAP_TAPCELL_ROW_33_484 vssd1 vccd1 sky130_fd_sc_hd__tapvpwrvgnd_1
X_3899_ _4804_/Q _4805_/Q vssd1 vssd1 vccd1 vccd1 _3899_/Y sky130_fd_sc_hd__nand2b_4
XFILLER_12_46 vssd1 vssd1 vccd1 vccd1 sky130_fd_sc_hd__fill_1
XFILLER_2_305 vssd1 vssd1 vccd1 vccd1 sky130_fd_sc_hd__fill_1
Xhold151 _4707_/Q vssd1 vssd1 vccd1 vccd1 hold151/X sky130_fd_sc_hd__dlygate4sd3_1
Xhold162 _4699_/Q vssd1 vssd1 vccd1 vccd1 hold162/X sky130_fd_sc_hd__dlygate4sd3_1
Xhold140 _4634_/Q vssd1 vssd1 vccd1 vccd1 hold140/X sky130_fd_sc_hd__dlygate4sd3_1
Xhold184 _4750_/Q vssd1 vssd1 vccd1 vccd1 hold184/X sky130_fd_sc_hd__dlygate4sd3_1
Xhold173 _4522_/Q vssd1 vssd1 vccd1 vccd1 hold173/X sky130_fd_sc_hd__dlygate4sd3_1
Xhold195 _4664_/Q vssd1 vssd1 vccd1 vccd1 hold195/X sky130_fd_sc_hd__dlygate4sd3_1
XANTENNA__4065__A2 _4081_/A2 vssd1 vssd1 vccd1 vccd1 sky130_fd_sc_hd__diode_2
XFILLER_33_209 vssd1 vssd1 vccd1 vccd1 sky130_fd_sc_hd__fill_1
XANTENNA__3812__A2 _3828_/A2 vssd1 vssd1 vccd1 vccd1 sky130_fd_sc_hd__diode_2
XFILLER_26_272 vccd1 vssd1 vccd1 vssd1 sky130_ef_sc_hd__decap_12
XFILLER_53_31 vssd1 vssd1 vccd1 vccd1 sky130_fd_sc_hd__fill_1
XFILLER_1_393 vssd1 vssd1 vccd1 vccd1 sky130_fd_sc_hd__fill_2
XFILLER_76_161 vssd1 vssd1 vccd1 vccd1 sky130_fd_sc_hd__decap_6
XFILLER_76_194 vssd1 vssd1 vccd1 vccd1 sky130_fd_sc_hd__fill_2
XFILLER_49_397 vssd1 vssd1 vccd1 vccd1 sky130_fd_sc_hd__decap_3
XTAP_TAPCELL_ROW_75_863 vssd1 vccd1 sky130_fd_sc_hd__tapvpwrvgnd_1
XFILLER_64_345 vccd1 vssd1 vccd1 vssd1 sky130_ef_sc_hd__decap_12
X_3822_ _4629_/Q _3830_/A2 _3821_/X _2654_/Y vssd1 vssd1 vccd1 vccd1 _4629_/D sky130_fd_sc_hd__a22o_1
XFILLER_32_253 vssd1 vssd1 vccd1 vccd1 sky130_fd_sc_hd__fill_2
X_3753_ _4534_/Q _4643_/Q vssd1 vssd1 vccd1 vccd1 _3754_/B sky130_fd_sc_hd__and2_1
X_2704_ _2753_/B _2705_/B _2753_/D _2705_/D vssd1 vssd1 vccd1 vccd1 _2706_/A sky130_fd_sc_hd__a22o_1
X_3684_ _3683_/Y _4601_/Q _3741_/S vssd1 vssd1 vccd1 vccd1 _4601_/D sky130_fd_sc_hd__mux2_1
X_2635_ _4740_/Q hold98/A vssd1 vssd1 vccd1 vccd1 _2636_/B sky130_fd_sc_hd__nor2_1
X_4305_ _4305_/A0 _4305_/A1 _4374_/S vssd1 vssd1 vccd1 vccd1 _4305_/X sky130_fd_sc_hd__mux2_1
X_2566_ _2528_/C _2526_/X _2590_/A _2559_/B _2563_/A vssd1 vssd1 vccd1 vccd1 _2584_/A
+ sky130_fd_sc_hd__o41a_1
X_2497_ _2497_/A _2497_/B vssd1 vssd1 vccd1 vccd1 _2501_/A sky130_fd_sc_hd__xor2_1
X_4236_ _4302_/D _4240_/A2 _4241_/B2 vssd1 vssd1 vccd1 vccd1 _4236_/Y sky130_fd_sc_hd__o21ai_1
XFILLER_4_91 vssd1 vssd1 vccd1 vccd1 sky130_fd_sc_hd__decap_3
X_4167_ _4167_/A0 _4167_/A1 _4372_/A vssd1 vssd1 vccd1 vccd1 _4167_/X sky130_fd_sc_hd__mux2_1
X_3118_ _4536_/Q _3156_/B1 _3103_/X _3117_/Y vssd1 vssd1 vccd1 vccd1 _4536_/D sky130_fd_sc_hd__o22a_1
XFILLER_55_334 vssd1 vssd1 vccd1 vccd1 sky130_fd_sc_hd__fill_2
XTAP_TAPCELL_ROW_38_532 vssd1 vccd1 sky130_fd_sc_hd__tapvpwrvgnd_1
X_4098_ _4097_/Y _4096_/X _4095_/X hold123/X _4224_/B1 vssd1 vssd1 vccd1 vccd1 _4716_/D
+ sky130_fd_sc_hd__o32a_1
X_3049_ _4753_/Q _3049_/B vssd1 vssd1 vccd1 vccd1 _3049_/Y sky130_fd_sc_hd__nor2_2
XFILLER_82_197 vssd1 vssd1 vccd1 vccd1 sky130_fd_sc_hd__decap_3
XANTENNA_fanout330_X _2304_/A1 vssd1 vssd1 vccd1 vccd1 sky130_fd_sc_hd__diode_2
XANTENNA__4359__S _4364_/A vssd1 vssd1 vccd1 vccd1 sky130_fd_sc_hd__diode_2
XFILLER_78_448 vssd1 vssd1 vccd1 vccd1 sky130_fd_sc_hd__decap_8
XFILLER_0_49 vssd1 vssd1 vccd1 vccd1 sky130_fd_sc_hd__decap_3
XFILLER_0_27 vssd1 vssd1 vccd1 vccd1 sky130_fd_sc_hd__fill_1
XFILLER_46_389 vccd1 vssd1 vccd1 vssd1 sky130_ef_sc_hd__decap_12
XTAP_TAPCELL_ROW_72_833 vssd1 vccd1 sky130_fd_sc_hd__tapvpwrvgnd_1
XFILLER_14_253 vssd1 vssd1 vccd1 vccd1 sky130_fd_sc_hd__fill_2
XFILLER_9_36 vccd1 vssd1 vccd1 vssd1 sky130_ef_sc_hd__decap_12
XFILLER_9_69 vssd1 vssd1 vccd1 vccd1 sky130_fd_sc_hd__fill_1
Xfanout90 _4397_/S vssd1 vssd1 vccd1 vccd1 _4402_/S sky130_fd_sc_hd__clkbuf_2
XFILLER_80_95 vssd1 vssd1 vccd1 vccd1 sky130_fd_sc_hd__decap_8
XFILLER_6_452 vccd1 vssd1 vccd1 vssd1 sky130_ef_sc_hd__decap_12
XFILLER_6_430 vssd1 vssd1 vccd1 vccd1 sky130_fd_sc_hd__decap_4
X_2420_ hold69/X _2419_/X _2420_/S vssd1 vssd1 vccd1 vccd1 _4505_/D sky130_fd_sc_hd__mux2_1
X_2351_ _4543_/Q hold71/A _2365_/S vssd1 vssd1 vccd1 vccd1 _2351_/X sky130_fd_sc_hd__mux2_1
XANTENNA__4269__S _4274_/D vssd1 vssd1 vccd1 vccd1 sky130_fd_sc_hd__diode_2
X_2282_ _4806_/Q _3873_/A _2295_/C vssd1 vssd1 vccd1 vccd1 _2282_/X sky130_fd_sc_hd__or3_1
XANTENNA__2288__A1 _4120_/D vssd1 vssd1 vccd1 vccd1 sky130_fd_sc_hd__diode_2
X_4021_ _4104_/C _4037_/B _4037_/C _4021_/D vssd1 vssd1 vccd1 vccd1 _4021_/X sky130_fd_sc_hd__and4b_1
XTAP_TAPCELL_ROW_35_502 vssd1 vccd1 sky130_fd_sc_hd__tapvpwrvgnd_1
XFILLER_64_197 vccd1 vssd1 vccd1 vssd1 sky130_ef_sc_hd__decap_12
XANTENNA__4017__B _4037_/B vssd1 vssd1 vccd1 vccd1 sky130_fd_sc_hd__diode_2
X_4785_ _4819_/CLK _4785_/D fanout403/X vssd1 vssd1 vccd1 vccd1 _4785_/Q sky130_fd_sc_hd__dfrtp_1
X_3805_ _2453_/Y _2459_/Y _2460_/Y vssd1 vssd1 vccd1 vccd1 _3805_/X sky130_fd_sc_hd__a21o_1
X_3736_ _3734_/A _3734_/B _3722_/Y vssd1 vssd1 vccd1 vccd1 _3740_/A sky130_fd_sc_hd__o21a_1
XANTENNA_fanout123_A _3928_/S vssd1 vssd1 vccd1 vccd1 sky130_fd_sc_hd__diode_2
XANTENNA__3960__A1 _4087_/S vssd1 vssd1 vccd1 vccd1 sky130_fd_sc_hd__diode_2
X_3667_ _4524_/Q _4633_/Q vssd1 vssd1 vccd1 vccd1 _3690_/B sky130_fd_sc_hd__nor2_1
X_3598_ _4515_/Q _4624_/Q _3595_/Y vssd1 vssd1 vccd1 vccd1 _3602_/A sky130_fd_sc_hd__a21boi_1
X_2618_ _2617_/A _2617_/B _2617_/C _2617_/D vssd1 vssd1 vccd1 vccd1 _2651_/A sky130_fd_sc_hd__a22oi_2
X_2549_ _2549_/A _2549_/B _4655_/Q vssd1 vssd1 vccd1 vccd1 _2551_/A sky130_fd_sc_hd__nor3b_1
XTAP_TAPCELL_ROW_7_249 vssd1 vccd1 sky130_fd_sc_hd__tapvpwrvgnd_1
X_4219_ _4243_/A2 _4239_/B _4219_/C _4223_/D vssd1 vssd1 vccd1 vccd1 _4219_/X sky130_fd_sc_hd__and4b_1
XANTENNA__2279__A1 _2310_/A1 vssd1 vssd1 vccd1 vccd1 sky130_fd_sc_hd__diode_2
XFILLER_43_337 vssd1 vssd1 vccd1 vccd1 sky130_fd_sc_hd__fill_2
XFILLER_55_197 vccd1 vssd1 vccd1 vssd1 sky130_ef_sc_hd__decap_12
XFILLER_70_167 vccd1 vssd1 vccd1 vssd1 sky130_ef_sc_hd__decap_12
XFILLER_11_256 vssd1 vssd1 vccd1 vccd1 sky130_fd_sc_hd__decap_8
XFILLER_11_289 vssd1 vssd1 vccd1 vccd1 sky130_fd_sc_hd__decap_3
XFILLER_11_267 vccd1 vssd1 vccd1 vssd1 sky130_ef_sc_hd__decap_12
XANTENNA__3400__B1 _3541_/B1 vssd1 vssd1 vccd1 vccd1 sky130_fd_sc_hd__diode_2
XANTENNA__3951__A1 _4075_/S vssd1 vssd1 vccd1 vccd1 sky130_fd_sc_hd__diode_2
XFILLER_3_422 vssd1 vssd1 vccd1 vccd1 sky130_fd_sc_hd__decap_8
XFILLER_66_418 vssd1 vssd1 vccd1 vccd1 sky130_fd_sc_hd__fill_2
Xfanout291 _4033_/C vssd1 vssd1 vccd1 vccd1 _4001_/C sky130_fd_sc_hd__buf_2
Xfanout280 _4811_/Q vssd1 vssd1 vccd1 vccd1 _4148_/C sky130_fd_sc_hd__clkbuf_2
XTAP_TAPCELL_ROW_49_627 vssd1 vccd1 sky130_fd_sc_hd__tapvpwrvgnd_1
XFILLER_61_101 vssd1 vssd1 vccd1 vccd1 sky130_fd_sc_hd__decap_4
XFILLER_61_123 vccd1 vssd1 vccd1 vssd1 sky130_ef_sc_hd__decap_12
XFILLER_42_392 vssd1 vssd1 vccd1 vccd1 sky130_fd_sc_hd__fill_1
X_4570_ _4612_/CLK _4570_/D fanout430/X vssd1 vssd1 vccd1 vccd1 _4570_/Q sky130_fd_sc_hd__dfrtp_2
X_3521_ _3507_/A _3524_/C _3520_/X _3525_/B1 vssd1 vssd1 vccd1 vccd1 _3521_/X sky130_fd_sc_hd__a31o_1
XTAP_TAPCELL_ROW_12_295 vssd1 vccd1 sky130_fd_sc_hd__tapvpwrvgnd_1
XANTENNA_clkbuf_leaf_3_clk_A clkload0/A vssd1 vssd1 vccd1 vccd1 sky130_fd_sc_hd__diode_2
X_3452_ _3195_/A _3195_/B _3197_/X _3451_/Y vssd1 vssd1 vccd1 vccd1 _3452_/X sky130_fd_sc_hd__a2bb2o_1
X_2403_ _4569_/Q hold42/A _2421_/S vssd1 vssd1 vccd1 vccd1 _2403_/X sky130_fd_sc_hd__mux2_1
X_3383_ _3383_/A1 _3382_/X _3383_/B1 vssd1 vssd1 vccd1 vccd1 _3383_/X sky130_fd_sc_hd__a21o_1
X_2334_ _2341_/A0 _2341_/A1 _4037_/D vssd1 vssd1 vccd1 vccd1 _2334_/X sky130_fd_sc_hd__mux2_1
XFILLER_84_215 vssd1 vssd1 vccd1 vccd1 sky130_fd_sc_hd__decap_3
X_2265_ hold63/X _4573_/Q _2270_/S vssd1 vssd1 vccd1 vccd1 _4444_/D sky130_fd_sc_hd__mux2_1
X_4004_ _4020_/A0 _4020_/A1 _4071_/S vssd1 vssd1 vccd1 vccd1 _4004_/X sky130_fd_sc_hd__mux2_1
XTAP_TAPCELL_ROW_83_939 vssd1 vccd1 sky130_fd_sc_hd__tapvpwrvgnd_1
XFILLER_1_81 vssd1 vssd1 vccd1 vccd1 sky130_fd_sc_hd__fill_1
XFILLER_25_337 vssd1 vssd1 vccd1 vccd1 sky130_fd_sc_hd__decap_4
XFILLER_40_307 vssd1 vssd1 vccd1 vccd1 sky130_fd_sc_hd__fill_1
XANTENNA_fanout338_A _4253_/S vssd1 vssd1 vccd1 vccd1 sky130_fd_sc_hd__diode_2
XANTENNA_fanout240_A _2250_/S vssd1 vssd1 vccd1 vccd1 sky130_fd_sc_hd__diode_2
XANTENNA__4186__A1 _4210_/A1 vssd1 vssd1 vccd1 vccd1 sky130_fd_sc_hd__diode_2
X_4768_ _4818_/CLK _4768_/D fanout396/X vssd1 vssd1 vccd1 vccd1 _4768_/Q sky130_fd_sc_hd__dfrtp_1
XANTENNA__3873__Y _3873_/Y vssd1 vssd1 vccd1 vccd1 sky130_fd_sc_hd__diode_2
XANTENNA_fanout126_X _3890_/S vssd1 vssd1 vccd1 vccd1 sky130_fd_sc_hd__diode_2
XFILLER_20_24 vssd1 vssd1 vccd1 vccd1 sky130_fd_sc_hd__fill_1
X_4699_ clkload9/A _4699_/D fanout387/X vssd1 vssd1 vccd1 vccd1 _4699_/Q sky130_fd_sc_hd__dfrtp_1
X_3719_ _3741_/S _4605_/Q vssd1 vssd1 vccd1 vccd1 _3719_/X sky130_fd_sc_hd__and2_1
XFILLER_20_35 vssd1 vssd1 vccd1 vccd1 sky130_fd_sc_hd__fill_1
XFILLER_20_68 vssd1 vssd1 vccd1 vccd1 sky130_fd_sc_hd__fill_1
Xhold22 hold22/A vssd1 vssd1 vccd1 vccd1 hold22/X sky130_fd_sc_hd__dlygate4sd3_1
Xhold11 hold11/A vssd1 vssd1 vccd1 vccd1 hold11/X sky130_fd_sc_hd__dlygate4sd3_1
XFILLER_48_407 vssd1 vssd1 vccd1 vccd1 sky130_fd_sc_hd__decap_4
Xhold55 hold55/A vssd1 vssd1 vccd1 vccd1 hold55/X sky130_fd_sc_hd__dlygate4sd3_1
Xhold33 hold33/A vssd1 vssd1 vccd1 vccd1 hold33/X sky130_fd_sc_hd__dlygate4sd3_1
Xhold44 hold44/A vssd1 vssd1 vccd1 vccd1 hold44/X sky130_fd_sc_hd__dlygate4sd3_1
Xhold66 hold66/A vssd1 vssd1 vccd1 vccd1 hold66/X sky130_fd_sc_hd__dlygate4sd3_1
Xhold77 hold77/A vssd1 vssd1 vccd1 vccd1 hold77/X sky130_fd_sc_hd__dlygate4sd3_1
XFILLER_75_259 vccd1 vssd1 vccd1 vssd1 sky130_ef_sc_hd__decap_12
XANTENNA__4110__A1 _4136_/B vssd1 vssd1 vccd1 vccd1 sky130_fd_sc_hd__diode_2
Xhold88 hold88/A vssd1 vssd1 vccd1 vccd1 hold88/X sky130_fd_sc_hd__dlygate4sd3_1
Xhold99 hold99/A vssd1 vssd1 vccd1 vccd1 hold99/X sky130_fd_sc_hd__dlygate4sd3_1
XFILLER_83_281 vccd1 vssd1 vccd1 vssd1 sky130_ef_sc_hd__decap_12
XFILLER_43_101 vssd1 vssd1 vccd1 vccd1 sky130_fd_sc_hd__decap_8
XFILLER_31_329 vssd1 vssd1 vccd1 vccd1 sky130_fd_sc_hd__decap_6
XPHY_EDGE_ROW_51_Left_139 vssd1 vssd1 vccd1 vccd1 sky130_fd_sc_hd__decap_3
XTAP_TAPCELL_ROW_54_674 vssd1 vccd1 sky130_fd_sc_hd__tapvpwrvgnd_1
XANTENNA__4104__C _4104_/C vssd1 vssd1 vccd1 vccd1 sky130_fd_sc_hd__diode_2
XANTENNA__4120__B _4136_/B vssd1 vssd1 vccd1 vccd1 sky130_fd_sc_hd__diode_2
XPHY_EDGE_ROW_60_Left_148 vssd1 vssd1 vccd1 vccd1 sky130_fd_sc_hd__decap_3
XFILLER_86_83 vssd1 vssd1 vccd1 vccd1 sky130_fd_sc_hd__fill_1
XFILLER_20_7 vssd1 vssd1 vccd1 vccd1 sky130_fd_sc_hd__fill_1
XFILLER_74_292 vssd1 vssd1 vccd1 vccd1 sky130_fd_sc_hd__decap_4
XFILLER_74_281 vssd1 vssd1 vccd1 vccd1 sky130_fd_sc_hd__decap_4
XTAP_TAPCELL_ROW_80_909 vssd1 vccd1 sky130_fd_sc_hd__tapvpwrvgnd_1
XTAP_TAPCELL_ROW_17_343 vssd1 vccd1 sky130_fd_sc_hd__tapvpwrvgnd_1
X_2952_ _2952_/A _2952_/B vssd1 vssd1 vccd1 vccd1 _2953_/B sky130_fd_sc_hd__nor2_1
XFILLER_30_340 vssd1 vssd1 vccd1 vccd1 sky130_fd_sc_hd__fill_2
XFILLER_30_362 vssd1 vssd1 vccd1 vccd1 sky130_fd_sc_hd__fill_2
X_2883_ _2917_/A _2877_/X _2883_/C _2883_/D vssd1 vssd1 vccd1 vccd1 _2917_/B sky130_fd_sc_hd__and4bb_1
X_4622_ _4624_/CLK _4622_/D fanout407/X vssd1 vssd1 vccd1 vccd1 _4622_/Q sky130_fd_sc_hd__dfrtp_1
X_4553_ _4553_/CLK _4553_/D fanout419/X vssd1 vssd1 vccd1 vccd1 _4553_/Q sky130_fd_sc_hd__dfrtp_1
X_3504_ _3311_/B _3504_/A2 _3504_/B1 _3543_/A vssd1 vssd1 vccd1 vccd1 _3504_/Y sky130_fd_sc_hd__o211ai_2
X_4484_ _4820_/CLK _4484_/D _2229_/B vssd1 vssd1 vccd1 vccd1 hold88/A sky130_fd_sc_hd__dfrtp_1
X_3435_ _4559_/Q _3540_/B2 _3433_/X _3434_/X vssd1 vssd1 vccd1 vccd1 _4559_/D sky130_fd_sc_hd__a22o_1
X_3366_ _3370_/B _3423_/A1 _3365_/X _3423_/B1 vssd1 vssd1 vccd1 vccd1 _3366_/X sky130_fd_sc_hd__a31o_1
X_2317_ hold122/X _3995_/B2 _2316_/X _2314_/X vssd1 vssd1 vccd1 vccd1 _4461_/D sky130_fd_sc_hd__o22a_1
X_3297_ _3289_/Y _3295_/X _3302_/B vssd1 vssd1 vccd1 vccd1 _3463_/A sky130_fd_sc_hd__a21boi_2
X_2248_ hold28/X _4556_/Q _2249_/S vssd1 vssd1 vccd1 vccd1 _4427_/D sky130_fd_sc_hd__mux2_1
XANTENNA__4754__Q _4754_/Q vssd1 vssd1 vccd1 vccd1 sky130_fd_sc_hd__diode_2
XTAP_TAPCELL_ROW_68_799 vssd1 vccd1 sky130_fd_sc_hd__tapvpwrvgnd_1
XFILLER_65_281 vssd1 vssd1 vccd1 vccd1 sky130_fd_sc_hd__decap_8
XFILLER_25_101 vssd1 vssd1 vccd1 vccd1 sky130_fd_sc_hd__fill_1
XFILLER_25_156 vssd1 vssd1 vccd1 vccd1 sky130_fd_sc_hd__decap_4
XTAP_TAPCELL_ROW_51_644 vssd1 vccd1 sky130_fd_sc_hd__tapvpwrvgnd_1
XANTENNA__4159__A1 _4167_/A1 vssd1 vssd1 vccd1 vccd1 sky130_fd_sc_hd__diode_2
XFILLER_31_89 vssd1 vssd1 vccd1 vccd1 sky130_fd_sc_hd__decap_3
Xoutput56 hold18/A vssd1 vssd1 vccd1 vccd1 m_axis_tdata[27] sky130_fd_sc_hd__buf_2
Xoutput45 hold3/A vssd1 vssd1 vccd1 vccd1 m_axis_tdata[17] sky130_fd_sc_hd__buf_2
Xoutput67 hold55/A vssd1 vssd1 vccd1 vccd1 m_axis_tdata[37] sky130_fd_sc_hd__buf_2
Xoutput78 _2229_/X vssd1 vssd1 vccd1 vccd1 s_axis_tready sky130_fd_sc_hd__buf_2
XTAP_TAPCELL_ROW_59_722 vssd1 vccd1 sky130_fd_sc_hd__tapvpwrvgnd_1
XFILLER_29_440 vssd1 vssd1 vccd1 vccd1 sky130_fd_sc_hd__decap_8
XANTENNA_input16_A s_axis_tdata[21] vssd1 vssd1 vccd1 vccd1 sky130_fd_sc_hd__diode_2
XFILLER_71_240 vccd1 vssd1 vccd1 vssd1 sky130_ef_sc_hd__decap_12
XTAP_TAPCELL_ROW_14_313 vssd1 vccd1 sky130_fd_sc_hd__tapvpwrvgnd_1
XANTENNA_clkbuf_2_0__f_clk_X clkload0/A vssd1 vssd1 vccd1 vccd1 sky130_fd_sc_hd__diode_2
XTAP_TAPCELL_ROW_22_390 vssd1 vccd1 sky130_fd_sc_hd__tapvpwrvgnd_1
XANTENNA__2350__S _2366_/S vssd1 vssd1 vccd1 vccd1 sky130_fd_sc_hd__diode_2
X_3220_ _4556_/Q _4597_/Q vssd1 vssd1 vccd1 vccd1 _3221_/B sky130_fd_sc_hd__nor2_1
XANTENNA__4322__B2 _4338_/A2 vssd1 vssd1 vccd1 vccd1 sky130_fd_sc_hd__diode_2
X_3151_ _3151_/A _3151_/B vssd1 vssd1 vccd1 vccd1 _3153_/B sky130_fd_sc_hd__xnor2_1
XFILLER_39_237 vssd1 vssd1 vccd1 vccd1 sky130_fd_sc_hd__decap_3
X_3082_ _4768_/Q _4783_/Q _3150_/A vssd1 vssd1 vccd1 vccd1 _3085_/B sky130_fd_sc_hd__a21o_1
XFILLER_47_281 vssd1 vssd1 vccd1 vccd1 sky130_fd_sc_hd__fill_1
XANTENNA__4009__C _4037_/C vssd1 vssd1 vccd1 vccd1 sky130_fd_sc_hd__diode_2
XFILLER_62_295 vssd1 vssd1 vccd1 vccd1 sky130_fd_sc_hd__decap_6
X_3984_ _4020_/A0 _4020_/A1 _3984_/S vssd1 vssd1 vccd1 vccd1 _3984_/X sky130_fd_sc_hd__mux2_1
X_2935_ _2873_/A _3862_/B _2975_/B _2934_/B vssd1 vssd1 vccd1 vccd1 _2940_/B sky130_fd_sc_hd__o2bb2a_1
XFILLER_22_159 vssd1 vssd1 vccd1 vccd1 sky130_fd_sc_hd__decap_8
XANTENNA__4025__B _4037_/B vssd1 vssd1 vccd1 vccd1 sky130_fd_sc_hd__diode_2
XFILLER_50_468 vssd1 vssd1 vccd1 vccd1 sky130_fd_sc_hd__decap_8
XFILLER_30_181 vccd1 vssd1 vccd1 vssd1 sky130_ef_sc_hd__decap_12
X_2866_ _4527_/Q _2985_/A2 _2849_/Y _2865_/Y vssd1 vssd1 vccd1 vccd1 _4527_/D sky130_fd_sc_hd__o22a_1
X_4605_ _4605_/CLK _4605_/D fanout426/X vssd1 vssd1 vccd1 vccd1 _4605_/Q sky130_fd_sc_hd__dfrtp_1
XANTENNA__2260__S _2270_/S vssd1 vssd1 vccd1 vccd1 sky130_fd_sc_hd__diode_2
X_2797_ hold191/X _2797_/A2 _2783_/A _2796_/Y vssd1 vssd1 vccd1 vccd1 _4525_/D sky130_fd_sc_hd__o22a_1
X_4536_ _4647_/CLK _4536_/D fanout428/X vssd1 vssd1 vccd1 vccd1 _4536_/Q sky130_fd_sc_hd__dfrtp_4
XFILLER_2_509 vssd1 vssd1 vccd1 vccd1 sky130_fd_sc_hd__fill_2
X_4467_ _4702_/CLK _4467_/D fanout386/X vssd1 vssd1 vccd1 vccd1 _4467_/Q sky130_fd_sc_hd__dfrtp_1
X_4398_ _4001_/C input13/X _4400_/S vssd1 vssd1 vccd1 vccd1 _4807_/D sky130_fd_sc_hd__mux2_1
X_3418_ _3423_/A1 _3416_/X _3417_/Y _3423_/B1 vssd1 vssd1 vccd1 vccd1 _3418_/X sky130_fd_sc_hd__a31o_1
XANTENNA_input8_A s_axis_tdata[14] vssd1 vssd1 vccd1 vccd1 sky130_fd_sc_hd__diode_2
X_3349_ _3266_/C _3266_/A _3266_/B vssd1 vssd1 vccd1 vccd1 _3350_/B sky130_fd_sc_hd__a21oi_1
XANTENNA__2324__B1 _3890_/S vssd1 vssd1 vccd1 vccd1 sky130_fd_sc_hd__diode_2
XFILLER_85_321 vssd1 vssd1 vccd1 vccd1 sky130_fd_sc_hd__fill_1
XFILLER_26_23 vssd1 vssd1 vccd1 vccd1 sky130_fd_sc_hd__decap_4
XTAP_TAPCELL_ROW_28_438 vssd1 vccd1 sky130_fd_sc_hd__tapvpwrvgnd_1
XANTENNA_fanout360_X _3504_/A2 vssd1 vssd1 vccd1 vccd1 sky130_fd_sc_hd__diode_2
XFILLER_53_251 vssd1 vssd1 vccd1 vccd1 sky130_fd_sc_hd__fill_1
XFILLER_9_119 vssd1 vssd1 vccd1 vccd1 sky130_fd_sc_hd__fill_1
XANTENNA_clkbuf_leaf_43_clk_A clkload2/A vssd1 vssd1 vccd1 vccd1 sky130_fd_sc_hd__diode_2
XFILLER_67_41 vssd1 vssd1 vccd1 vccd1 sky130_fd_sc_hd__decap_3
XFILLER_76_321 vssd1 vssd1 vccd1 vccd1 sky130_fd_sc_hd__decap_8
XFILLER_76_365 vssd1 vssd1 vccd1 vccd1 sky130_fd_sc_hd__decap_8
XFILLER_76_354 vssd1 vssd1 vccd1 vccd1 sky130_fd_sc_hd__decap_8
XFILLER_29_281 vssd1 vssd1 vccd1 vccd1 sky130_fd_sc_hd__decap_4
XFILLER_83_51 vssd1 vssd1 vccd1 vccd1 sky130_fd_sc_hd__decap_4
XFILLER_17_454 vccd1 vssd1 vccd1 vssd1 sky130_ef_sc_hd__decap_12
XFILLER_32_457 vssd1 vssd1 vccd1 vccd1 sky130_fd_sc_hd__fill_1
XFILLER_80_6 vssd1 vssd1 vccd1 vccd1 sky130_fd_sc_hd__fill_1
X_2720_ _2717_/Y _2718_/X _2678_/X _2682_/X vssd1 vssd1 vccd1 vccd1 _2722_/C sky130_fd_sc_hd__a211oi_1
X_2651_ _2651_/A _2651_/B vssd1 vssd1 vccd1 vccd1 _2653_/B sky130_fd_sc_hd__xor2_1
X_2582_ _2582_/A _2582_/B vssd1 vssd1 vccd1 vccd1 _2584_/B sky130_fd_sc_hd__nand2_1
XFILLER_59_3 vssd1 vssd1 vccd1 vccd1 sky130_fd_sc_hd__decap_4
X_4321_ _4320_/A _4344_/B _4338_/A2 vssd1 vssd1 vccd1 vccd1 _4321_/Y sky130_fd_sc_hd__o21ai_1
Xfanout109 _3828_/A2 vssd1 vssd1 vccd1 vccd1 _3795_/S sky130_fd_sc_hd__buf_2
X_4252_ _4251_/Y _4250_/X _4249_/X hold212/X _4264_/B2 vssd1 vssd1 vccd1 vccd1 _4755_/D
+ sky130_fd_sc_hd__o32a_1
XFILLER_86_129 vssd1 vssd1 vccd1 vccd1 sky130_fd_sc_hd__fill_1
XANTENNA__3503__C1 _3543_/A vssd1 vssd1 vccd1 vccd1 sky130_fd_sc_hd__diode_2
X_3203_ _3458_/B _3203_/B _3447_/A _3295_/C vssd1 vssd1 vccd1 vccd1 _3203_/Y sky130_fd_sc_hd__nand4_1
X_4183_ _4258_/C _4211_/B _4199_/D _4313_/S vssd1 vssd1 vccd1 vccd1 _4183_/X sky130_fd_sc_hd__and4b_1
X_3134_ _3134_/A _3134_/B vssd1 vssd1 vccd1 vccd1 _3135_/B sky130_fd_sc_hd__xor2_1
XANTENNA__4059__A0 _4099_/A0 vssd1 vssd1 vccd1 vccd1 sky130_fd_sc_hd__diode_2
XFILLER_55_505 vssd1 vssd1 vccd1 vccd1 sky130_fd_sc_hd__fill_1
XTAP_TAPCELL_ROW_78_894 vssd1 vccd1 sky130_fd_sc_hd__tapvpwrvgnd_1
X_3065_ _3066_/B _3066_/A vssd1 vssd1 vccd1 vccd1 _3065_/X sky130_fd_sc_hd__and2_1
XFILLER_27_218 vssd1 vssd1 vccd1 vccd1 sky130_fd_sc_hd__fill_2
XFILLER_82_357 vssd1 vssd1 vccd1 vccd1 sky130_fd_sc_hd__decap_6
XFILLER_35_251 vssd1 vssd1 vccd1 vccd1 sky130_fd_sc_hd__fill_1
X_3967_ hold128/X _4015_/B2 _3966_/X vssd1 vssd1 vccd1 vccd1 _4682_/D sky130_fd_sc_hd__o21ba_1
XFILLER_50_265 vssd1 vssd1 vccd1 vccd1 sky130_fd_sc_hd__decap_4
XANTENNA_fanout320_A _2311_/A vssd1 vssd1 vccd1 vccd1 sky130_fd_sc_hd__diode_2
XTAP_TAPCELL_ROW_33_485 vssd1 vccd1 sky130_fd_sc_hd__tapvpwrvgnd_1
X_2918_ _2880_/B _2880_/A _2880_/C vssd1 vssd1 vccd1 vccd1 _2918_/X sky130_fd_sc_hd__o21ba_1
XANTENNA_fanout418_A fanout424/X vssd1 vssd1 vccd1 vccd1 sky130_fd_sc_hd__diode_2
X_3898_ _4339_/A0 hold179/X _4314_/S vssd1 vssd1 vccd1 vccd1 _4657_/D sky130_fd_sc_hd__mux2_1
Xclkbuf_leaf_30_clk clkbuf_2_3__f_clk/X vssd1 vssd1 vccd1 vccd1 _4562_/CLK sky130_fd_sc_hd__clkbuf_8
X_2849_ _2850_/A _2850_/B _2850_/C vssd1 vssd1 vccd1 vccd1 _2849_/Y sky130_fd_sc_hd__a21oi_1
XANTENNA_fanout206_X _2310_/A1 vssd1 vssd1 vccd1 vccd1 sky130_fd_sc_hd__diode_2
Xhold152 _4514_/Q vssd1 vssd1 vccd1 vccd1 hold152/X sky130_fd_sc_hd__dlygate4sd3_1
X_4519_ _4631_/CLK _4519_/D fanout410/X vssd1 vssd1 vccd1 vccd1 _4519_/Q sky130_fd_sc_hd__dfrtp_1
Xhold141 _4696_/Q vssd1 vssd1 vccd1 vccd1 hold141/X sky130_fd_sc_hd__dlygate4sd3_1
Xhold130 _4665_/Q vssd1 vssd1 vccd1 vccd1 hold130/X sky130_fd_sc_hd__dlygate4sd3_1
Xhold163 _4456_/Q vssd1 vssd1 vccd1 vccd1 hold163/X sky130_fd_sc_hd__dlygate4sd3_1
Xhold174 _4726_/Q vssd1 vssd1 vccd1 vccd1 hold174/X sky130_fd_sc_hd__dlygate4sd3_1
Xhold185 _4757_/Q vssd1 vssd1 vccd1 vccd1 hold185/X sky130_fd_sc_hd__dlygate4sd3_1
Xhold196 _4727_/Q vssd1 vssd1 vccd1 vccd1 hold196/X sky130_fd_sc_hd__dlygate4sd3_1
XFILLER_37_33 vssd1 vssd1 vccd1 vccd1 sky130_fd_sc_hd__fill_1
XFILLER_58_365 vssd1 vssd1 vccd1 vccd1 sky130_fd_sc_hd__decap_8
XFILLER_18_218 vccd1 vssd1 vccd1 vssd1 sky130_ef_sc_hd__decap_12
XFILLER_73_346 vssd1 vssd1 vccd1 vccd1 sky130_fd_sc_hd__decap_4
XFILLER_26_284 vssd1 vssd1 vccd1 vccd1 sky130_fd_sc_hd__decap_3
XFILLER_53_43 vssd1 vssd1 vccd1 vccd1 sky130_fd_sc_hd__decap_6
Xclkbuf_leaf_21_clk clkbuf_2_3__f_clk/X vssd1 vssd1 vccd1 vccd1 _4644_/CLK sky130_fd_sc_hd__clkbuf_8
XFILLER_78_51 vccd1 vssd1 vccd1 vssd1 sky130_ef_sc_hd__decap_12
XTAP_TAPCELL_ROW_75_864 vssd1 vccd1 sky130_fd_sc_hd__tapvpwrvgnd_1
XFILLER_64_357 vssd1 vssd1 vccd1 vccd1 sky130_fd_sc_hd__decap_6
XFILLER_32_232 vccd1 vssd1 vccd1 vssd1 sky130_ef_sc_hd__decap_12
XFILLER_20_405 vccd1 vssd1 vccd1 vssd1 sky130_ef_sc_hd__decap_12
X_3821_ _3821_/A _3821_/B vssd1 vssd1 vccd1 vccd1 _3821_/X sky130_fd_sc_hd__or2_1
XFILLER_32_276 vssd1 vssd1 vccd1 vccd1 sky130_fd_sc_hd__decap_6
X_3752_ _4534_/Q _4643_/Q vssd1 vssd1 vccd1 vccd1 _3754_/A sky130_fd_sc_hd__nor2_1
Xclkbuf_leaf_12_clk clkload1/A vssd1 vssd1 vccd1 vccd1 _4751_/CLK sky130_fd_sc_hd__clkbuf_8
XTAP_TAPCELL_ROW_30_455 vssd1 vccd1 sky130_fd_sc_hd__tapvpwrvgnd_1
X_2703_ _2699_/X _2701_/Y _4465_/Q vssd1 vssd1 vccd1 vccd1 _2705_/D sky130_fd_sc_hd__o21bai_1
X_3683_ _3683_/A _3685_/B vssd1 vssd1 vccd1 vccd1 _3683_/Y sky130_fd_sc_hd__xnor2_1
X_2634_ _4740_/Q hold98/A vssd1 vssd1 vccd1 vccd1 _2636_/A sky130_fd_sc_hd__and2_1
X_2565_ _2553_/Y _2564_/X _4518_/Q _2565_/B2 vssd1 vssd1 vccd1 vccd1 _4518_/D sky130_fd_sc_hd__o2bb2a_1
X_4304_ _4303_/Y _4302_/X _4301_/X _4768_/Q _4378_/B2 vssd1 vssd1 vccd1 vccd1 _4768_/D
+ sky130_fd_sc_hd__o32a_1
XFILLER_4_70 vssd1 vssd1 vccd1 vccd1 sky130_fd_sc_hd__decap_8
X_2496_ _4458_/Q _2496_/B vssd1 vssd1 vccd1 vccd1 _2497_/B sky130_fd_sc_hd__xnor2_1
X_4235_ _4178_/D _4814_/Q _4368_/A _4239_/D vssd1 vssd1 vccd1 vccd1 _4235_/X sky130_fd_sc_hd__and4b_1
XFILLER_4_81 vssd1 vssd1 vccd1 vccd1 sky130_fd_sc_hd__decap_3
X_4166_ _4163_/X _4164_/X _4165_/Y _4209_/B2 hold92/X vssd1 vssd1 vccd1 vccd1 _4733_/D
+ sky130_fd_sc_hd__o32a_1
X_3117_ _3117_/A vssd1 vssd1 vccd1 vccd1 _3117_/Y sky130_fd_sc_hd__inv_2
XANTENNA_fanout270_A _4239_/D vssd1 vssd1 vccd1 vccd1 sky130_fd_sc_hd__diode_2
XTAP_TAPCELL_ROW_38_533 vssd1 vccd1 sky130_fd_sc_hd__tapvpwrvgnd_1
X_4097_ _4231_/C _4105_/A2 _4224_/B1 vssd1 vssd1 vccd1 vccd1 _4097_/Y sky130_fd_sc_hd__o21ai_1
X_3048_ _4753_/Q _3049_/B vssd1 vssd1 vccd1 vccd1 _3050_/C sky130_fd_sc_hd__nand2_4
XFILLER_23_232 vssd1 vssd1 vccd1 vccd1 sky130_fd_sc_hd__decap_8
XFILLER_23_46 vssd1 vssd1 vccd1 vccd1 sky130_fd_sc_hd__fill_2
XANTENNA_fanout323_X _2311_/A vssd1 vssd1 vccd1 vccd1 sky130_fd_sc_hd__diode_2
XFILLER_23_57 vssd1 vssd1 vccd1 vccd1 sky130_fd_sc_hd__fill_2
XFILLER_2_114 vccd1 vssd1 vccd1 vssd1 sky130_ef_sc_hd__decap_12
Xfanout440 input2/X vssd1 vssd1 vccd1 vccd1 fanout440/X sky130_fd_sc_hd__clkbuf_2
XFILLER_58_173 vssd1 vssd1 vccd1 vccd1 sky130_fd_sc_hd__fill_1
XTAP_TAPCELL_ROW_72_834 vssd1 vccd1 sky130_fd_sc_hd__tapvpwrvgnd_1
XFILLER_14_298 vssd1 vssd1 vccd1 vccd1 sky130_fd_sc_hd__fill_2
XFILLER_9_48 vssd1 vssd1 vccd1 vccd1 sky130_fd_sc_hd__decap_8
Xfanout91 _4411_/S vssd1 vssd1 vccd1 vccd1 _4397_/S sky130_fd_sc_hd__clkbuf_2
Xfanout80 _3333_/Y vssd1 vssd1 vccd1 vccd1 _3423_/A1 sky130_fd_sc_hd__buf_2
XFILLER_6_464 vccd1 vssd1 vccd1 vssd1 sky130_ef_sc_hd__decap_12
X_2350_ hold22/X _2349_/X _2366_/S vssd1 vssd1 vccd1 vccd1 _4470_/D sky130_fd_sc_hd__mux2_1
XFILLER_69_449 vssd1 vssd1 vccd1 vccd1 sky130_fd_sc_hd__decap_3
X_2281_ _3875_/A0 _2310_/A1 _3985_/D vssd1 vssd1 vccd1 vccd1 _2281_/X sky130_fd_sc_hd__mux2_1
Xclkbuf_leaf_1_clk clkload0/A vssd1 vssd1 vccd1 vccd1 clkload4/A sky130_fd_sc_hd__clkbuf_8
X_4020_ _4020_/A0 _4020_/A1 _4087_/S vssd1 vssd1 vccd1 vccd1 _4020_/X sky130_fd_sc_hd__mux2_1
XFILLER_64_154 vssd1 vssd1 vccd1 vccd1 sky130_fd_sc_hd__fill_2
XTAP_TAPCELL_ROW_35_503 vssd1 vccd1 sky130_fd_sc_hd__tapvpwrvgnd_1
XFILLER_52_327 vssd1 vssd1 vccd1 vccd1 sky130_fd_sc_hd__fill_1
XANTENNA__4017__C _4037_/C vssd1 vssd1 vccd1 vccd1 sky130_fd_sc_hd__diode_2
X_4784_ _4819_/CLK _4784_/D fanout402/X vssd1 vssd1 vccd1 vccd1 _4784_/Q sky130_fd_sc_hd__dfrtp_1
X_3804_ hold223/X _3795_/S _3803_/Y vssd1 vssd1 vccd1 vccd1 _4620_/D sky130_fd_sc_hd__a21o_1
XTAP_TAPCELL_ROW_43_580 vssd1 vccd1 sky130_fd_sc_hd__tapvpwrvgnd_1
XANTENNA__4033__B _4037_/B vssd1 vssd1 vccd1 vccd1 sky130_fd_sc_hd__diode_2
X_3735_ _3734_/X _4606_/Q _3735_/S vssd1 vssd1 vccd1 vccd1 _4606_/D sky130_fd_sc_hd__mux2_1
XANTENNA__3960__A2 _3873_/Y vssd1 vssd1 vccd1 vccd1 sky130_fd_sc_hd__diode_2
XANTENNA_fanout116_A _2797_/A2 vssd1 vssd1 vccd1 vccd1 sky130_fd_sc_hd__diode_2
X_3666_ _3690_/A _3660_/Y _3662_/Y vssd1 vssd1 vccd1 vccd1 _3670_/A sky130_fd_sc_hd__o21a_1
Xclkload50 _4635_/CLK vssd1 vssd1 vccd1 vccd1 clkload50/Y sky130_fd_sc_hd__inv_6
X_3597_ _4590_/Q _3603_/S _3596_/X _3595_/Y vssd1 vssd1 vccd1 vccd1 _4590_/D sky130_fd_sc_hd__a22o_1
X_2617_ _2617_/A _2617_/B _2617_/C _2617_/D vssd1 vssd1 vccd1 vccd1 _2621_/C sky130_fd_sc_hd__nand4_2
X_2548_ _2543_/X _2545_/Y _4460_/Q vssd1 vssd1 vccd1 vccd1 _2549_/B sky130_fd_sc_hd__o21ba_1
X_2479_ _4457_/Q _2479_/B vssd1 vssd1 vccd1 vccd1 _2481_/B sky130_fd_sc_hd__xor2_1
X_4218_ _4238_/A0 _4238_/A1 _4223_/C vssd1 vssd1 vccd1 vccd1 _4218_/X sky130_fd_sc_hd__mux2_1
XTAP_TAPCELL_ROW_86_959 vssd1 vccd1 sky130_fd_sc_hd__tapvpwrvgnd_1
XFILLER_83_441 vssd1 vssd1 vccd1 vccd1 sky130_fd_sc_hd__fill_2
X_4149_ _4215_/C _4176_/A2 _4208_/B1 vssd1 vssd1 vccd1 vccd1 _4149_/Y sky130_fd_sc_hd__o21ai_1
XFILLER_55_132 vssd1 vssd1 vccd1 vccd1 sky130_fd_sc_hd__decap_6
XANTENNA_fanout440_X fanout440/X vssd1 vssd1 vccd1 vccd1 sky130_fd_sc_hd__diode_2
XFILLER_70_179 vccd1 vssd1 vccd1 vssd1 sky130_ef_sc_hd__decap_12
XFILLER_11_279 vssd1 vssd1 vccd1 vccd1 sky130_fd_sc_hd__fill_1
Xclkload0 clkload0/A vssd1 vssd1 vccd1 vccd1 clkload0/X sky130_fd_sc_hd__clkbuf_8
XFILLER_59_86 vssd1 vssd1 vccd1 vccd1 sky130_fd_sc_hd__decap_8
Xfanout270 _4239_/D vssd1 vssd1 vccd1 vccd1 _4231_/D sky130_fd_sc_hd__clkbuf_2
Xfanout281 _4104_/B vssd1 vssd1 vccd1 vccd1 _4068_/B sky130_fd_sc_hd__clkbuf_2
XFILLER_19_302 vssd1 vssd1 vccd1 vccd1 sky130_fd_sc_hd__decap_6
Xfanout292 _4033_/C vssd1 vssd1 vccd1 vccd1 _4037_/C sky130_fd_sc_hd__buf_2
XTAP_TAPCELL_ROW_49_628 vssd1 vccd1 sky130_fd_sc_hd__tapvpwrvgnd_1
XFILLER_59_482 vssd1 vssd1 vccd1 vccd1 sky130_fd_sc_hd__fill_1
XFILLER_75_52 vssd1 vssd1 vccd1 vccd1 sky130_fd_sc_hd__fill_2
XFILLER_74_452 vssd1 vssd1 vccd1 vccd1 sky130_fd_sc_hd__fill_1
XANTENNA__2353__S _2365_/S vssd1 vssd1 vccd1 vccd1 sky130_fd_sc_hd__diode_2
XTAP_TAPCELL_ROW_40_550 vssd1 vccd1 sky130_fd_sc_hd__tapvpwrvgnd_1
X_3520_ _3309_/B _3516_/B _3313_/D _3307_/X vssd1 vssd1 vccd1 vccd1 _3520_/X sky130_fd_sc_hd__a211o_1
XTAP_TAPCELL_ROW_12_296 vssd1 vccd1 sky130_fd_sc_hd__tapvpwrvgnd_1
X_3451_ _3442_/A _3442_/B _3217_/X vssd1 vssd1 vccd1 vccd1 _3451_/Y sky130_fd_sc_hd__o21bai_2
X_2402_ hold18/X _2401_/X _2420_/S vssd1 vssd1 vccd1 vccd1 _4496_/D sky130_fd_sc_hd__mux2_1
X_3382_ _3382_/A _3382_/B vssd1 vssd1 vccd1 vccd1 _3382_/X sky130_fd_sc_hd__or2_1
XFILLER_41_3 vssd1 vssd1 vccd1 vccd1 sky130_fd_sc_hd__fill_1
X_2333_ hold153/X _4038_/B1 _2332_/X _2330_/X vssd1 vssd1 vccd1 vccd1 _4465_/D sky130_fd_sc_hd__o22a_1
X_2264_ hold77/X _4572_/Q _2270_/S vssd1 vssd1 vccd1 vccd1 _4443_/D sky130_fd_sc_hd__mux2_1
X_4003_ _4002_/Y _4001_/X _4000_/X hold214/X _4058_/B2 vssd1 vssd1 vccd1 vccd1 _4692_/D
+ sky130_fd_sc_hd__o32a_1
XFILLER_80_411 vssd1 vssd1 vccd1 vccd1 sky130_fd_sc_hd__decap_8
XFILLER_80_477 vssd1 vssd1 vccd1 vccd1 sky130_fd_sc_hd__decap_4
XFILLER_52_168 vssd1 vssd1 vccd1 vccd1 sky130_fd_sc_hd__fill_1
XANTENNA__2263__S _2270_/S vssd1 vssd1 vccd1 vccd1 sky130_fd_sc_hd__diode_2
X_4767_ _4819_/CLK _4767_/D fanout402/X vssd1 vssd1 vccd1 vccd1 _4767_/Q sky130_fd_sc_hd__dfrtp_1
X_4698_ _4774_/CLK _4698_/D fanout387/X vssd1 vssd1 vccd1 vccd1 _4698_/Q sky130_fd_sc_hd__dfrtp_1
X_3718_ _3705_/Y _3711_/Y _3716_/A _3716_/B vssd1 vssd1 vccd1 vccd1 _3718_/X sky130_fd_sc_hd__a211o_1
X_3649_ _3648_/Y _4596_/Q _3655_/S vssd1 vssd1 vccd1 vccd1 _4596_/D sky130_fd_sc_hd__mux2_1
XFILLER_0_415 vssd1 vssd1 vccd1 vccd1 sky130_fd_sc_hd__fill_1
Xhold12 hold12/A vssd1 vssd1 vccd1 vccd1 hold12/X sky130_fd_sc_hd__dlygate4sd3_1
Xhold23 hold23/A vssd1 vssd1 vccd1 vccd1 hold23/X sky130_fd_sc_hd__dlygate4sd3_1
Xhold45 hold45/A vssd1 vssd1 vccd1 vccd1 hold45/X sky130_fd_sc_hd__dlygate4sd3_1
XTAP_TAPCELL_ROW_3_220 vssd1 vccd1 sky130_fd_sc_hd__tapvpwrvgnd_1
Xhold56 hold56/A vssd1 vssd1 vccd1 vccd1 hold56/X sky130_fd_sc_hd__dlygate4sd3_1
Xhold34 hold34/A vssd1 vssd1 vccd1 vccd1 hold34/X sky130_fd_sc_hd__dlygate4sd3_1
Xhold89 hold89/A vssd1 vssd1 vccd1 vccd1 hold89/X sky130_fd_sc_hd__dlygate4sd3_1
Xhold67 hold67/A vssd1 vssd1 vccd1 vccd1 hold67/X sky130_fd_sc_hd__dlygate4sd3_1
XFILLER_56_441 vssd1 vssd1 vccd1 vccd1 sky130_fd_sc_hd__decap_6
Xhold78 hold78/A vssd1 vssd1 vccd1 vccd1 hold78/X sky130_fd_sc_hd__dlygate4sd3_1
XFILLER_83_293 vccd1 vssd1 vccd1 vssd1 sky130_ef_sc_hd__decap_12
XFILLER_71_411 vccd1 vssd1 vccd1 vssd1 sky130_ef_sc_hd__decap_12
XFILLER_45_44 vssd1 vssd1 vccd1 vccd1 sky130_fd_sc_hd__fill_1
XFILLER_45_55 vssd1 vssd1 vccd1 vccd1 sky130_fd_sc_hd__fill_1
XTAP_TAPCELL_ROW_54_675 vssd1 vccd1 sky130_fd_sc_hd__tapvpwrvgnd_1
XANTENNA__4104__D _4372_/A vssd1 vssd1 vccd1 vccd1 sky130_fd_sc_hd__diode_2
XFILLER_6_49 vssd1 vssd1 vccd1 vccd1 sky130_fd_sc_hd__fill_1
XANTENNA__3924__A2 _2274_/B vssd1 vssd1 vccd1 vccd1 sky130_fd_sc_hd__diode_2
XANTENNA__2348__S _2366_/S vssd1 vssd1 vccd1 vccd1 sky130_fd_sc_hd__diode_2
XANTENNA__4101__A2 _4105_/A2 vssd1 vssd1 vccd1 vccd1 sky130_fd_sc_hd__diode_2
XANTENNA__4207__A_N _4258_/C vssd1 vssd1 vccd1 vccd1 sky130_fd_sc_hd__diode_2
XFILLER_34_124 vssd1 vssd1 vccd1 vccd1 sky130_fd_sc_hd__fill_2
XTAP_TAPCELL_ROW_17_344 vssd1 vccd1 sky130_fd_sc_hd__tapvpwrvgnd_1
XFILLER_62_477 vssd1 vssd1 vccd1 vccd1 sky130_fd_sc_hd__fill_1
X_2951_ _2947_/X _2951_/B _2951_/C vssd1 vssd1 vccd1 vccd1 _2952_/B sky130_fd_sc_hd__and3b_1
XFILLER_15_360 vccd1 vssd1 vccd1 vssd1 sky130_ef_sc_hd__decap_12
XFILLER_34_179 vssd1 vssd1 vccd1 vccd1 sky130_fd_sc_hd__fill_2
XFILLER_15_393 vccd1 vssd1 vccd1 vssd1 sky130_ef_sc_hd__decap_12
X_4621_ _4624_/CLK _4621_/D fanout409/X vssd1 vssd1 vccd1 vccd1 _4621_/Q sky130_fd_sc_hd__dfrtp_2
XANTENNA_clkbuf_0_clk_A clk vssd1 vssd1 vccd1 vccd1 sky130_fd_sc_hd__diode_2
X_2882_ _2883_/C _2883_/D vssd1 vssd1 vccd1 vccd1 _2882_/Y sky130_fd_sc_hd__nand2_1
X_4552_ _4553_/CLK _4552_/D fanout423/X vssd1 vssd1 vccd1 vccd1 _4552_/Q sky130_fd_sc_hd__dfrtp_4
XANTENNA__3915__A2 _4212_/A2 vssd1 vssd1 vccd1 vccd1 sky130_fd_sc_hd__diode_2
X_3503_ _3308_/B _3503_/A2 _3504_/B1 _3543_/A vssd1 vssd1 vccd1 vccd1 _3503_/X sky130_fd_sc_hd__o211a_2
X_4483_ _4820_/CLK _4483_/D _2229_/B vssd1 vssd1 vccd1 vccd1 hold1/A sky130_fd_sc_hd__dfrtp_1
X_3434_ _4600_/Q _3504_/A2 _3477_/B1 _3923_/A vssd1 vssd1 vccd1 vccd1 _3434_/X sky130_fd_sc_hd__o211a_1
X_3365_ _3359_/C _3273_/A _3273_/B vssd1 vssd1 vccd1 vccd1 _3365_/X sky130_fd_sc_hd__a21o_1
X_2316_ _4075_/S _2335_/C _2335_/B _3890_/S _2315_/Y vssd1 vssd1 vccd1 vccd1 _2316_/X
+ sky130_fd_sc_hd__a311o_1
X_3296_ _3254_/X _3288_/Y _3295_/X vssd1 vssd1 vccd1 vccd1 _3302_/A sky130_fd_sc_hd__o21ai_2
X_2247_ hold14/X _4555_/Q _2249_/S vssd1 vssd1 vccd1 vccd1 _4426_/D sky130_fd_sc_hd__mux2_1
XFILLER_57_238 vssd1 vssd1 vccd1 vccd1 sky130_fd_sc_hd__fill_1
XFILLER_38_441 vssd1 vssd1 vccd1 vccd1 sky130_fd_sc_hd__fill_1
XFILLER_25_113 vssd1 vssd1 vccd1 vccd1 sky130_fd_sc_hd__fill_1
XFILLER_80_263 vssd1 vssd1 vccd1 vccd1 sky130_fd_sc_hd__decap_8
XFILLER_53_499 vssd1 vssd1 vccd1 vccd1 sky130_fd_sc_hd__fill_1
XFILLER_40_149 vssd1 vssd1 vccd1 vccd1 sky130_fd_sc_hd__decap_4
XTAP_TAPCELL_ROW_51_645 vssd1 vccd1 sky130_fd_sc_hd__tapvpwrvgnd_1
XFILLER_21_352 vccd1 vssd1 vccd1 vssd1 sky130_ef_sc_hd__decap_12
X_4819_ _4819_/CLK _4819_/D fanout403/X vssd1 vssd1 vccd1 vccd1 _4819_/Q sky130_fd_sc_hd__dfrtp_1
XANTENNA__3906__A2 _4022_/A2 vssd1 vssd1 vccd1 vccd1 sky130_fd_sc_hd__diode_2
XANTENNA__3367__B1 _3541_/B1 vssd1 vssd1 vccd1 vccd1 sky130_fd_sc_hd__diode_2
XFILLER_31_57 vssd1 vssd1 vccd1 vccd1 sky130_fd_sc_hd__decap_6
Xoutput57 hold59/A vssd1 vssd1 vccd1 vccd1 m_axis_tdata[28] sky130_fd_sc_hd__buf_2
Xoutput46 hold5/A vssd1 vssd1 vccd1 vccd1 m_axis_tdata[18] sky130_fd_sc_hd__buf_2
XFILLER_0_223 vssd1 vssd1 vccd1 vccd1 sky130_fd_sc_hd__fill_1
Xoutput68 hold17/A vssd1 vssd1 vccd1 vccd1 m_axis_tdata[38] sky130_fd_sc_hd__buf_2
XFILLER_48_238 vssd1 vssd1 vccd1 vccd1 sky130_fd_sc_hd__fill_1
XTAP_TAPCELL_ROW_59_723 vssd1 vccd1 sky130_fd_sc_hd__tapvpwrvgnd_1
XFILLER_56_54 vssd1 vssd1 vccd1 vccd1 sky130_fd_sc_hd__fill_1
XANTENNA_clkbuf_leaf_2_clk_A clkload0/A vssd1 vssd1 vccd1 vccd1 sky130_fd_sc_hd__diode_2
XANTENNA__2645__A2 _4754_/Q vssd1 vssd1 vccd1 vccd1 sky130_fd_sc_hd__diode_2
XPHY_EDGE_ROW_19_Right_19 vssd1 vssd1 vccd1 vccd1 sky130_fd_sc_hd__decap_3
XFILLER_71_252 vccd1 vssd1 vccd1 vssd1 sky130_ef_sc_hd__decap_12
XTAP_TAPCELL_ROW_14_314 vssd1 vccd1 sky130_fd_sc_hd__tapvpwrvgnd_1
XFILLER_31_138 vssd1 vssd1 vccd1 vccd1 sky130_fd_sc_hd__fill_1
XFILLER_12_363 vssd1 vssd1 vccd1 vccd1 sky130_fd_sc_hd__fill_1
XFILLER_12_385 vssd1 vssd1 vccd1 vccd1 sky130_fd_sc_hd__decap_8
XTAP_TAPCELL_ROW_22_391 vssd1 vccd1 sky130_fd_sc_hd__tapvpwrvgnd_1
XPHY_EDGE_ROW_28_Right_28 vssd1 vssd1 vccd1 vccd1 sky130_fd_sc_hd__decap_3
XANTENNA__2867__A _4702_/Q vssd1 vssd1 vccd1 vccd1 sky130_fd_sc_hd__diode_2
X_3150_ _3150_/A _3150_/B vssd1 vssd1 vccd1 vccd1 _3151_/B sky130_fd_sc_hd__xnor2_1
XFILLER_67_514 vssd1 vssd1 vccd1 vccd1 sky130_fd_sc_hd__fill_1
X_3081_ _3025_/A _3049_/Y _3050_/C vssd1 vssd1 vccd1 vccd1 _3151_/A sky130_fd_sc_hd__o21ai_4
XPHY_EDGE_ROW_37_Right_37 vssd1 vssd1 vccd1 vccd1 sky130_fd_sc_hd__decap_3
XFILLER_47_271 vssd1 vssd1 vccd1 vccd1 sky130_fd_sc_hd__decap_8
XANTENNA__4293__S _4364_/A vssd1 vssd1 vccd1 vccd1 sky130_fd_sc_hd__diode_2
XANTENNA__4009__D _4071_/S vssd1 vssd1 vccd1 vccd1 sky130_fd_sc_hd__diode_2
X_3983_ _3982_/Y _3981_/X _3980_/X _4687_/Q _3983_/B2 vssd1 vssd1 vccd1 vccd1 _4687_/D
+ sky130_fd_sc_hd__o32a_1
X_2934_ _2975_/B _2934_/B _3074_/C vssd1 vssd1 vccd1 vccd1 _2940_/A sky130_fd_sc_hd__nor3_2
XANTENNA__4025__C _4037_/C vssd1 vssd1 vccd1 vccd1 sky130_fd_sc_hd__diode_2
X_2865_ _2851_/Y _2864_/X _2985_/A2 vssd1 vssd1 vccd1 vccd1 _2865_/Y sky130_fd_sc_hd__o21ai_1
XFILLER_30_193 vssd1 vssd1 vccd1 vccd1 sky130_fd_sc_hd__decap_3
XANTENNA__4010__A1 _4071_/S vssd1 vssd1 vccd1 vccd1 sky130_fd_sc_hd__diode_2
XPHY_EDGE_ROW_46_Right_46 vssd1 vssd1 vccd1 vccd1 sky130_fd_sc_hd__decap_3
X_4604_ _4605_/CLK _4604_/D fanout426/X vssd1 vssd1 vccd1 vccd1 _4604_/Q sky130_fd_sc_hd__dfrtp_1
X_4535_ _4644_/CLK _4535_/D fanout428/X vssd1 vssd1 vccd1 vccd1 _4535_/Q sky130_fd_sc_hd__dfrtp_1
X_2796_ _2783_/X _2795_/Y _3870_/B1 vssd1 vssd1 vccd1 vccd1 _2796_/Y sky130_fd_sc_hd__o21ai_1
X_4466_ _4702_/CLK _4466_/D fanout386/X vssd1 vssd1 vccd1 vccd1 _4466_/Q sky130_fd_sc_hd__dfrtp_1
X_4397_ hold183/X input12/X _4397_/S vssd1 vssd1 vccd1 vccd1 _4806_/D sky130_fd_sc_hd__mux2_1
X_3417_ _3225_/A _3412_/A _3226_/B vssd1 vssd1 vccd1 vccd1 _3417_/Y sky130_fd_sc_hd__o21ai_1
X_3348_ _4543_/Q _3425_/A2 _3346_/X _3347_/X vssd1 vssd1 vccd1 vccd1 _4543_/D sky130_fd_sc_hd__a22o_1
XANTENNA_fanout398_A fanout404/X vssd1 vssd1 vccd1 vccd1 sky130_fd_sc_hd__diode_2
XANTENNA_fanout186_X _4020_/A0 vssd1 vssd1 vccd1 vccd1 sky130_fd_sc_hd__diode_2
X_3279_ _3243_/Y _3279_/B vssd1 vssd1 vccd1 vccd1 _3380_/C sky130_fd_sc_hd__and2b_1
XANTENNA__4077__A1 _4273_/S vssd1 vssd1 vccd1 vccd1 sky130_fd_sc_hd__diode_2
XFILLER_45_208 vssd1 vssd1 vccd1 vccd1 sky130_fd_sc_hd__decap_4
XPHY_EDGE_ROW_55_Right_55 vssd1 vssd1 vccd1 vccd1 sky130_fd_sc_hd__decap_3
XTAP_TAPCELL_ROW_28_439 vssd1 vccd1 sky130_fd_sc_hd__tapvpwrvgnd_1
XANTENNA_fanout353_X _3946_/A1 vssd1 vssd1 vccd1 vccd1 sky130_fd_sc_hd__diode_2
XFILLER_13_105 vssd1 vssd1 vccd1 vccd1 sky130_fd_sc_hd__fill_1
XFILLER_13_149 vssd1 vssd1 vccd1 vccd1 sky130_fd_sc_hd__fill_1
XPHY_EDGE_ROW_64_Right_64 vssd1 vssd1 vccd1 vccd1 sky130_fd_sc_hd__decap_3
XFILLER_42_45 vssd1 vssd1 vccd1 vccd1 sky130_fd_sc_hd__fill_1
XFILLER_5_337 vssd1 vssd1 vccd1 vccd1 sky130_fd_sc_hd__fill_2
XANTENNA_fanout99_X _3735_/S vssd1 vssd1 vccd1 vccd1 sky130_fd_sc_hd__diode_2
XFILLER_49_514 vssd1 vssd1 vccd1 vccd1 sky130_fd_sc_hd__fill_1
XPHY_EDGE_ROW_73_Right_73 vssd1 vssd1 vccd1 vccd1 sky130_fd_sc_hd__decap_3
XFILLER_67_75 vssd1 vssd1 vccd1 vccd1 sky130_fd_sc_hd__fill_1
XFILLER_17_466 vccd1 vssd1 vccd1 vssd1 sky130_ef_sc_hd__decap_12
XPHY_EDGE_ROW_82_Right_82 vssd1 vssd1 vccd1 vccd1 sky130_fd_sc_hd__decap_3
XFILLER_12_182 vssd1 vssd1 vccd1 vccd1 sky130_fd_sc_hd__decap_3
XANTENNA__2361__S _2369_/S vssd1 vssd1 vccd1 vccd1 sky130_fd_sc_hd__diode_2
X_2650_ _2651_/A _2651_/B vssd1 vssd1 vccd1 vccd1 _2690_/A sky130_fd_sc_hd__nand2_1
X_2581_ _2580_/A _2580_/B _2580_/C vssd1 vssd1 vccd1 vccd1 _2582_/B sky130_fd_sc_hd__o21ai_1
X_4320_ _4320_/A _4328_/B _4328_/C vssd1 vssd1 vccd1 vccd1 _4320_/X sky130_fd_sc_hd__and3_1
X_4251_ _4313_/S _4279_/A2 _4264_/B2 vssd1 vssd1 vccd1 vccd1 _4251_/Y sky130_fd_sc_hd__o21ai_1
XANTENNA__2306__A1 _2310_/A1 vssd1 vssd1 vccd1 vccd1 sky130_fd_sc_hd__diode_2
X_3202_ _3202_/A _3202_/B vssd1 vssd1 vccd1 vccd1 _3442_/A sky130_fd_sc_hd__or2_1
XFILLER_79_182 vssd1 vssd1 vccd1 vccd1 sky130_fd_sc_hd__fill_1
X_4182_ _4214_/A0 _4210_/A1 _4789_/Q vssd1 vssd1 vccd1 vccd1 _4182_/X sky130_fd_sc_hd__mux2_1
X_3133_ _3133_/A _3133_/B vssd1 vssd1 vccd1 vccd1 _3134_/B sky130_fd_sc_hd__nor2_1
XANTENNA__4059__A1 _4083_/A1 vssd1 vssd1 vccd1 vccd1 sky130_fd_sc_hd__diode_2
XTAP_TAPCELL_ROW_78_895 vssd1 vccd1 sky130_fd_sc_hd__tapvpwrvgnd_1
X_3064_ _3064_/A _3064_/B vssd1 vssd1 vccd1 vccd1 _3066_/B sky130_fd_sc_hd__nor2_1
XANTENNA__2490__B1 _4666_/Q vssd1 vssd1 vccd1 vccd1 sky130_fd_sc_hd__diode_2
XTAP_TAPCELL_ROW_61_740 vssd1 vccd1 sky130_fd_sc_hd__tapvpwrvgnd_1
X_3966_ _4033_/D _3873_/Y _3965_/X _4015_/B2 vssd1 vssd1 vccd1 vccd1 _3966_/X sky130_fd_sc_hd__o211a_1
XANTENNA_fanout146_A _2273_/X vssd1 vssd1 vccd1 vccd1 sky130_fd_sc_hd__diode_2
XTAP_TAPCELL_ROW_33_486 vssd1 vccd1 sky130_fd_sc_hd__tapvpwrvgnd_1
X_2917_ _2917_/A _2917_/B vssd1 vssd1 vccd1 vccd1 _2928_/A sky130_fd_sc_hd__nor2_1
X_3897_ _4371_/C _4373_/B _4371_/B vssd1 vssd1 vccd1 vccd1 _3897_/Y sky130_fd_sc_hd__nor3_1
XANTENNA__2271__S _2271_/S vssd1 vssd1 vccd1 vccd1 sky130_fd_sc_hd__diode_2
XANTENNA_fanout313_A _4797_/Q vssd1 vssd1 vccd1 vccd1 sky130_fd_sc_hd__diode_2
X_2848_ _2848_/A _2848_/B vssd1 vssd1 vccd1 vccd1 _2850_/C sky130_fd_sc_hd__xor2_1
X_2779_ _2766_/X _2767_/Y _2775_/Y _2776_/X vssd1 vssd1 vccd1 vccd1 _2780_/B sky130_fd_sc_hd__a211oi_1
Xhold131 _4786_/Q vssd1 vssd1 vccd1 vccd1 hold131/X sky130_fd_sc_hd__dlygate4sd3_1
X_4518_ _4702_/CLK _4518_/D fanout410/X vssd1 vssd1 vccd1 vccd1 _4518_/Q sky130_fd_sc_hd__dfrtp_2
Xhold153 _4465_/Q vssd1 vssd1 vccd1 vccd1 hold153/X sky130_fd_sc_hd__dlygate4sd3_1
Xhold142 _4697_/Q vssd1 vssd1 vccd1 vccd1 hold142/X sky130_fd_sc_hd__dlygate4sd3_1
Xhold120 _4746_/Q vssd1 vssd1 vccd1 vccd1 hold120/X sky130_fd_sc_hd__dlygate4sd3_1
Xhold175 _4642_/Q vssd1 vssd1 vccd1 vccd1 hold175/X sky130_fd_sc_hd__dlygate4sd3_1
X_4449_ _4579_/CLK _4449_/D fanout433/X vssd1 vssd1 vccd1 vccd1 hold39/A sky130_fd_sc_hd__dfrtp_1
Xhold186 _4513_/Q vssd1 vssd1 vccd1 vccd1 hold186/X sky130_fd_sc_hd__dlygate4sd3_1
XANTENNA__4198__S _4203_/C vssd1 vssd1 vccd1 vccd1 sky130_fd_sc_hd__diode_2
Xhold164 _4761_/Q vssd1 vssd1 vccd1 vccd1 hold164/X sky130_fd_sc_hd__dlygate4sd3_1
Xhold197 _4591_/Q vssd1 vssd1 vccd1 vccd1 hold197/X sky130_fd_sc_hd__dlygate4sd3_1
XFILLER_14_414 vssd1 vssd1 vccd1 vccd1 sky130_fd_sc_hd__decap_6
XFILLER_41_211 vssd1 vssd1 vccd1 vccd1 sky130_fd_sc_hd__decap_8
XFILLER_41_255 vssd1 vssd1 vccd1 vccd1 sky130_fd_sc_hd__fill_2
XFILLER_53_55 vssd1 vssd1 vccd1 vccd1 sky130_fd_sc_hd__fill_1
XANTENNA__3576__A3 _3549_/A vssd1 vssd1 vccd1 vccd1 sky130_fd_sc_hd__diode_2
XFILLER_53_99 vssd1 vssd1 vccd1 vccd1 sky130_fd_sc_hd__decap_3
XFILLER_78_85 vssd1 vssd1 vccd1 vccd1 sky130_fd_sc_hd__decap_6
XFILLER_78_63 vssd1 vssd1 vccd1 vccd1 sky130_fd_sc_hd__decap_4
XTAP_TAPCELL_ROW_75_865 vssd1 vccd1 sky130_fd_sc_hd__tapvpwrvgnd_1
XANTENNA__2356__S _2366_/S vssd1 vssd1 vccd1 vccd1 sky130_fd_sc_hd__diode_2
XFILLER_17_252 vccd1 vssd1 vccd1 vssd1 sky130_ef_sc_hd__decap_12
XFILLER_72_380 vssd1 vssd1 vccd1 vccd1 sky130_fd_sc_hd__decap_4
XFILLER_32_222 vssd1 vssd1 vccd1 vccd1 sky130_fd_sc_hd__fill_1
X_3820_ hold193/X _3830_/A2 _3819_/Y vssd1 vssd1 vccd1 vccd1 _4628_/D sky130_fd_sc_hd__a21o_1
XFILLER_32_244 vssd1 vssd1 vccd1 vccd1 sky130_fd_sc_hd__decap_8
XFILLER_32_266 vssd1 vssd1 vccd1 vccd1 sky130_fd_sc_hd__fill_1
X_3751_ _3748_/A _3748_/B _3759_/A vssd1 vssd1 vccd1 vccd1 _3756_/B sky130_fd_sc_hd__a21oi_1
XFILLER_20_417 vssd1 vssd1 vccd1 vccd1 sky130_fd_sc_hd__decap_3
XFILLER_9_440 vssd1 vssd1 vccd1 vccd1 sky130_fd_sc_hd__decap_3
X_2702_ _2701_/Y _4465_/Q _2753_/C vssd1 vssd1 vccd1 vccd1 _2753_/D sky130_fd_sc_hd__nand3b_1
XTAP_TAPCELL_ROW_30_456 vssd1 vccd1 sky130_fd_sc_hd__tapvpwrvgnd_1
X_3682_ _4526_/Q _4635_/Q vssd1 vssd1 vccd1 vccd1 _3685_/B sky130_fd_sc_hd__xor2_1
X_2633_ _2632_/A _2632_/B _2632_/C vssd1 vssd1 vccd1 vccd1 _2638_/B sky130_fd_sc_hd__a21o_1
X_2564_ _3815_/A _3815_/B _4666_/Q _2274_/A vssd1 vssd1 vccd1 vccd1 _2564_/X sky130_fd_sc_hd__o211a_1
X_4303_ _4302_/D _4307_/A2 _4378_/B2 vssd1 vssd1 vccd1 vccd1 _4303_/Y sky130_fd_sc_hd__o21ai_1
X_2495_ _4458_/Q _2496_/B vssd1 vssd1 vccd1 vccd1 _2528_/B sky130_fd_sc_hd__nand2_1
X_4234_ _4238_/A0 _4238_/A1 _4371_/A vssd1 vssd1 vccd1 vccd1 _4234_/X sky130_fd_sc_hd__mux2_1
X_4165_ _4231_/C _4176_/A2 _4209_/B2 vssd1 vssd1 vccd1 vccd1 _4165_/Y sky130_fd_sc_hd__o21ai_1
X_3116_ _3114_/Y _3115_/Y _3103_/X _3156_/B1 vssd1 vssd1 vccd1 vccd1 _3117_/A sky130_fd_sc_hd__o31a_1
XFILLER_55_314 vccd1 vssd1 vccd1 vssd1 sky130_ef_sc_hd__decap_12
XANTENNA__2266__S _2271_/S vssd1 vssd1 vccd1 vccd1 sky130_fd_sc_hd__diode_2
XTAP_TAPCELL_ROW_38_534 vssd1 vccd1 sky130_fd_sc_hd__tapvpwrvgnd_1
X_4096_ _4168_/C _4104_/B _4100_/C _4231_/C vssd1 vssd1 vccd1 vccd1 _4096_/X sky130_fd_sc_hd__and4b_1
X_3047_ _4753_/Q _3049_/B vssd1 vssd1 vccd1 vccd1 _3047_/X sky130_fd_sc_hd__and2_1
XFILLER_63_391 vssd1 vssd1 vccd1 vccd1 sky130_fd_sc_hd__fill_1
XANTENNA_fanout430_A fanout440/X vssd1 vssd1 vccd1 vccd1 sky130_fd_sc_hd__diode_2
XANTENNA_clkbuf_leaf_42_clk_A clkload2/A vssd1 vssd1 vccd1 vccd1 sky130_fd_sc_hd__diode_2
XANTENNA__4204__A1 _4203_/C vssd1 vssd1 vccd1 vccd1 sky130_fd_sc_hd__diode_2
XFILLER_11_417 vssd1 vssd1 vccd1 vccd1 sky130_fd_sc_hd__decap_4
X_3949_ hold198/X _3999_/B2 _3948_/X vssd1 vssd1 vccd1 vccd1 _4676_/D sky130_fd_sc_hd__o21ba_1
XANTENNA_fanout316_X _4075_/S vssd1 vssd1 vccd1 vccd1 sky130_fd_sc_hd__diode_2
XFILLER_2_126 vccd1 vssd1 vccd1 vssd1 sky130_ef_sc_hd__decap_12
XFILLER_78_406 vccd1 vssd1 vccd1 vssd1 sky130_ef_sc_hd__decap_12
Xfanout430 fanout440/X vssd1 vssd1 vccd1 vccd1 fanout430/X sky130_fd_sc_hd__buf_2
XFILLER_48_11 vssd1 vssd1 vccd1 vccd1 sky130_fd_sc_hd__decap_3
XFILLER_46_325 vssd1 vssd1 vccd1 vccd1 sky130_fd_sc_hd__fill_1
XFILLER_0_29 vccd1 vssd1 vccd1 vssd1 sky130_ef_sc_hd__decap_12
XTAP_TAPCELL_ROW_72_835 vssd1 vccd1 sky130_fd_sc_hd__tapvpwrvgnd_1
Xfanout92 _4410_/S vssd1 vssd1 vccd1 vccd1 _4408_/S sky130_fd_sc_hd__clkbuf_4
Xfanout81 _3460_/A1 vssd1 vssd1 vccd1 vccd1 _3536_/A2 sky130_fd_sc_hd__buf_2
XANTENNA__2205__A _4001_/C vssd1 vssd1 vccd1 vccd1 sky130_fd_sc_hd__diode_2
XANTENNA__3735__S _3735_/S vssd1 vssd1 vccd1 vccd1 sky130_fd_sc_hd__diode_2
XTAP_TAPCELL_ROW_9_270 vssd1 vccd1 sky130_fd_sc_hd__tapvpwrvgnd_1
X_2280_ _2279_/X hold124/X _3928_/S vssd1 vssd1 vccd1 vccd1 _4452_/D sky130_fd_sc_hd__mux2_1
XANTENNA__4131__A0 _4167_/A0 vssd1 vssd1 vccd1 vccd1 sky130_fd_sc_hd__diode_2
XFILLER_77_483 vssd1 vssd1 vccd1 vccd1 sky130_fd_sc_hd__fill_1
XFILLER_49_152 vccd1 vssd1 vccd1 vssd1 sky130_ef_sc_hd__decap_12
XFILLER_64_111 vccd1 vssd1 vccd1 vssd1 sky130_ef_sc_hd__decap_12
XTAP_TAPCELL_ROW_35_504 vssd1 vccd1 sky130_fd_sc_hd__tapvpwrvgnd_1
X_3803_ _2442_/Y _2448_/Y _2449_/Y vssd1 vssd1 vccd1 vccd1 _3803_/Y sky130_fd_sc_hd__a21oi_1
XANTENNA__4198__A0 _4214_/A0 vssd1 vssd1 vccd1 vccd1 sky130_fd_sc_hd__diode_2
XFILLER_60_361 vssd1 vssd1 vccd1 vccd1 sky130_fd_sc_hd__fill_1
X_4783_ _4819_/CLK _4783_/D fanout402/X vssd1 vssd1 vccd1 vccd1 _4783_/Q sky130_fd_sc_hd__dfrtp_1
X_3734_ _3734_/A _3734_/B vssd1 vssd1 vccd1 vccd1 _3734_/X sky130_fd_sc_hd__xor2_1
XANTENNA__4033__C _4033_/C vssd1 vssd1 vccd1 vccd1 sky130_fd_sc_hd__diode_2
X_3665_ _3664_/Y _4598_/Q _3741_/S vssd1 vssd1 vccd1 vccd1 _4598_/D sky130_fd_sc_hd__mux2_1
Xclkload40 _4644_/CLK vssd1 vssd1 vccd1 vccd1 clkload40/Y sky130_fd_sc_hd__inv_6
X_2616_ _2580_/B _2580_/C _2580_/A vssd1 vssd1 vccd1 vccd1 _2623_/A sky130_fd_sc_hd__o21bai_4
X_3596_ _3587_/A _3590_/Y _3594_/X _3561_/C _3613_/B vssd1 vssd1 vccd1 vccd1 _3596_/X
+ sky130_fd_sc_hd__o311a_1
XANTENNA_fanout109_A _3828_/A2 vssd1 vssd1 vccd1 vccd1 sky130_fd_sc_hd__diode_2
X_2547_ _2545_/Y _4460_/Q _2588_/C vssd1 vssd1 vccd1 vccd1 _2588_/D sky130_fd_sc_hd__nand3b_2
XFILLER_87_225 vccd1 vssd1 vccd1 vssd1 sky130_ef_sc_hd__decap_12
X_2478_ _4457_/Q _2479_/B vssd1 vssd1 vccd1 vccd1 _2478_/Y sky130_fd_sc_hd__nand2_1
XANTENNA_fanout380_A fanout382/X vssd1 vssd1 vccd1 vccd1 sky130_fd_sc_hd__diode_2
X_4217_ _4216_/Y _4215_/X _4214_/X hold120/X _4224_/B1 vssd1 vssd1 vccd1 vccd1 _4746_/D
+ sky130_fd_sc_hd__o32a_1
X_4148_ _4239_/D _4175_/B _4148_/C _4215_/C vssd1 vssd1 vccd1 vccd1 _4148_/X sky130_fd_sc_hd__and4b_1
XANTENNA_fanout266_X _4211_/B vssd1 vssd1 vccd1 vccd1 sky130_fd_sc_hd__diode_2
X_4079_ _4103_/A0 _4083_/A1 _4219_/C vssd1 vssd1 vccd1 vccd1 _4079_/X sky130_fd_sc_hd__mux2_1
XFILLER_55_177 vssd1 vssd1 vccd1 vccd1 sky130_fd_sc_hd__fill_1
XFILLER_34_57 vssd1 vssd1 vccd1 vccd1 sky130_fd_sc_hd__decap_8
Xclkload1 clkload1/A vssd1 vssd1 vccd1 vccd1 clkload1/X sky130_fd_sc_hd__clkbuf_8
XFILLER_50_78 vssd1 vssd1 vccd1 vccd1 sky130_fd_sc_hd__fill_1
XFILLER_59_10 vssd1 vssd1 vccd1 vccd1 sky130_fd_sc_hd__decap_4
XANTENNA__4361__B1 _4361_/B1 vssd1 vssd1 vccd1 vccd1 sky130_fd_sc_hd__diode_2
XFILLER_3_446 vssd1 vssd1 vccd1 vccd1 sky130_fd_sc_hd__fill_2
XFILLER_59_76 vssd1 vssd1 vccd1 vccd1 sky130_fd_sc_hd__fill_2
XTAP_TAPCELL_ROW_6_240 vssd1 vccd1 sky130_fd_sc_hd__tapvpwrvgnd_1
Xfanout271 _4813_/Q vssd1 vssd1 vccd1 vccd1 _4239_/D sky130_fd_sc_hd__buf_2
Xfanout282 _4810_/Q vssd1 vssd1 vccd1 vccd1 _4104_/B sky130_fd_sc_hd__buf_2
XFILLER_19_314 vccd1 vssd1 vccd1 vssd1 sky130_ef_sc_hd__decap_12
XTAP_TAPCELL_ROW_49_629 vssd1 vccd1 sky130_fd_sc_hd__tapvpwrvgnd_1
Xfanout260 _4815_/Q vssd1 vssd1 vccd1 vccd1 _4270_/C sky130_fd_sc_hd__buf_1
XFILLER_75_64 vssd1 vssd1 vccd1 vccd1 sky130_fd_sc_hd__fill_1
Xfanout293 _4807_/Q vssd1 vssd1 vccd1 vccd1 _4033_/C sky130_fd_sc_hd__clkbuf_2
XFILLER_46_155 vssd1 vssd1 vccd1 vccd1 sky130_fd_sc_hd__fill_1
XFILLER_74_486 vssd1 vssd1 vccd1 vccd1 sky130_fd_sc_hd__decap_8
XFILLER_46_199 vccd1 vssd1 vccd1 vssd1 sky130_ef_sc_hd__decap_12
XFILLER_61_169 vssd1 vssd1 vccd1 vccd1 sky130_fd_sc_hd__fill_1
XFILLER_27_391 vssd1 vssd1 vccd1 vccd1 sky130_fd_sc_hd__fill_1
XANTENNA__3927__A0 _3872_/X vssd1 vssd1 vccd1 vccd1 sky130_fd_sc_hd__diode_2
XTAP_TAPCELL_ROW_40_551 vssd1 vccd1 sky130_fd_sc_hd__tapvpwrvgnd_1
XTAP_TAPCELL_ROW_12_297 vssd1 vccd1 sky130_fd_sc_hd__tapvpwrvgnd_1
X_3450_ _4562_/Q _3534_/A2 _3448_/X _3449_/X vssd1 vssd1 vccd1 vccd1 _4562_/D sky130_fd_sc_hd__a22o_1
X_2401_ _4568_/Q hold62/A _2421_/S vssd1 vssd1 vccd1 vccd1 _2401_/X sky130_fd_sc_hd__mux2_1
X_3381_ _3380_/A _3380_/B _3380_/C vssd1 vssd1 vccd1 vccd1 _3382_/B sky130_fd_sc_hd__a21oi_1
XFILLER_69_225 vccd1 vssd1 vccd1 vssd1 sky130_ef_sc_hd__decap_12
X_2332_ _4029_/D _2335_/C _2335_/B _3975_/S _2331_/Y vssd1 vssd1 vccd1 vccd1 _2332_/X
+ sky130_fd_sc_hd__a311o_1
XFILLER_34_3 vssd1 vssd1 vccd1 vccd1 sky130_fd_sc_hd__fill_1
XFILLER_69_269 vssd1 vssd1 vccd1 vccd1 sky130_fd_sc_hd__decap_3
X_2263_ hold89/X _4571_/Q _2270_/S vssd1 vssd1 vccd1 vccd1 _4442_/D sky130_fd_sc_hd__mux2_1
X_4002_ _4063_/S _4022_/A2 _4058_/B2 vssd1 vssd1 vccd1 vccd1 _4002_/Y sky130_fd_sc_hd__o21ai_1
XFILLER_33_383 vssd1 vssd1 vccd1 vccd1 sky130_fd_sc_hd__fill_1
X_4766_ _4782_/CLK _4766_/D fanout396/X vssd1 vssd1 vccd1 vccd1 _4766_/Q sky130_fd_sc_hd__dfrtp_1
XANTENNA_fanout226_A _4173_/A2 vssd1 vssd1 vccd1 vccd1 sky130_fd_sc_hd__diode_2
XANTENNA__3394__A1 _3423_/A1 vssd1 vssd1 vccd1 vccd1 sky130_fd_sc_hd__diode_2
X_3717_ _3716_/A _3716_/B _3705_/Y _3711_/Y vssd1 vssd1 vccd1 vccd1 _3717_/Y sky130_fd_sc_hd__o211ai_1
X_4697_ _4774_/CLK _4697_/D fanout386/X vssd1 vssd1 vccd1 vccd1 _4697_/Q sky130_fd_sc_hd__dfrtp_1
X_3648_ _3648_/A _3656_/B vssd1 vssd1 vccd1 vccd1 _3648_/Y sky130_fd_sc_hd__xnor2_1
X_3579_ _3579_/A _3579_/B vssd1 vssd1 vccd1 vccd1 _3579_/X sky130_fd_sc_hd__and2_1
XANTENNA__3697__A2 _3741_/S vssd1 vssd1 vccd1 vccd1 sky130_fd_sc_hd__diode_2
Xhold13 hold13/A vssd1 vssd1 vccd1 vccd1 hold13/X sky130_fd_sc_hd__dlygate4sd3_1
Xhold24 hold24/A vssd1 vssd1 vccd1 vccd1 hold24/X sky130_fd_sc_hd__dlygate4sd3_1
Xhold35 hold35/A vssd1 vssd1 vccd1 vccd1 hold35/X sky130_fd_sc_hd__dlygate4sd3_1
XANTENNA__3449__A2 _3504_/A2 vssd1 vssd1 vccd1 vccd1 sky130_fd_sc_hd__diode_2
Xhold46 hold46/A vssd1 vssd1 vccd1 vccd1 hold46/X sky130_fd_sc_hd__dlygate4sd3_1
Xhold68 hold68/A vssd1 vssd1 vccd1 vccd1 hold68/X sky130_fd_sc_hd__dlygate4sd3_1
Xhold79 hold79/A vssd1 vssd1 vccd1 vccd1 hold79/X sky130_fd_sc_hd__dlygate4sd3_1
Xhold57 hold57/A vssd1 vssd1 vccd1 vccd1 hold57/X sky130_fd_sc_hd__dlygate4sd3_1
XTAP_TAPCELL_ROW_82_930 vssd1 vccd1 sky130_fd_sc_hd__tapvpwrvgnd_1
XFILLER_71_423 vssd1 vssd1 vccd1 vccd1 sky130_fd_sc_hd__decap_8
XANTENNA__4009__A_N _4009_/A_N vssd1 vssd1 vccd1 vccd1 sky130_fd_sc_hd__diode_2
XFILLER_43_136 vccd1 vssd1 vccd1 vssd1 sky130_ef_sc_hd__decap_12
XFILLER_43_169 vccd1 vssd1 vccd1 vssd1 sky130_ef_sc_hd__decap_12
XTAP_TAPCELL_ROW_54_676 vssd1 vccd1 sky130_fd_sc_hd__tapvpwrvgnd_1
XANTENNA__3924__A3 _2369_/S vssd1 vssd1 vccd1 vccd1 sky130_fd_sc_hd__diode_2
XFILLER_79_501 vssd1 vssd1 vccd1 vccd1 sky130_fd_sc_hd__fill_1
XANTENNA__4120__D _4120_/D vssd1 vssd1 vccd1 vccd1 sky130_fd_sc_hd__diode_2
XFILLER_86_41 vccd1 vssd1 vccd1 vssd1 sky130_ef_sc_hd__decap_12
XFILLER_86_85 vccd1 vssd1 vccd1 vssd1 sky130_ef_sc_hd__decap_12
XFILLER_47_431 vccd1 vssd1 vccd1 vssd1 sky130_ef_sc_hd__decap_12
XFILLER_81_209 vccd1 vssd1 vccd1 vssd1 sky130_ef_sc_hd__decap_12
XFILLER_19_133 vssd1 vssd1 vccd1 vccd1 sky130_fd_sc_hd__decap_3
XFILLER_62_412 vssd1 vssd1 vccd1 vccd1 sky130_fd_sc_hd__decap_8
XFILLER_19_177 vssd1 vssd1 vccd1 vccd1 sky130_fd_sc_hd__fill_2
XTAP_TAPCELL_ROW_17_345 vssd1 vccd1 sky130_fd_sc_hd__tapvpwrvgnd_1
X_2950_ _2951_/B _2951_/C _2947_/X vssd1 vssd1 vccd1 vccd1 _2952_/A sky130_fd_sc_hd__a21boi_1
XFILLER_15_372 vssd1 vssd1 vccd1 vccd1 sky130_fd_sc_hd__fill_2
XANTENNA__2364__S _2366_/S vssd1 vssd1 vccd1 vccd1 sky130_fd_sc_hd__diode_2
X_2881_ _2880_/C _2880_/A _2880_/B vssd1 vssd1 vccd1 vccd1 _2883_/D sky130_fd_sc_hd__o21ai_1
X_4620_ _4669_/CLK _4620_/D fanout406/X vssd1 vssd1 vccd1 vccd1 _4620_/Q sky130_fd_sc_hd__dfrtp_1
X_4551_ _4593_/CLK _4551_/D fanout413/X vssd1 vssd1 vccd1 vccd1 _4551_/Q sky130_fd_sc_hd__dfrtp_2
X_3502_ _4571_/Q _3522_/A2 _3500_/X _3501_/X vssd1 vssd1 vccd1 vccd1 _4571_/D sky130_fd_sc_hd__a22o_1
X_4482_ _4820_/CLK _4482_/D fanout420/X vssd1 vssd1 vccd1 vccd1 hold9/A sky130_fd_sc_hd__dfrtp_1
X_3433_ _3460_/A1 _3432_/X _3460_/B1 vssd1 vssd1 vccd1 vccd1 _3433_/X sky130_fd_sc_hd__a21o_1
XANTENNA__4325__B1 _4376_/A2 vssd1 vssd1 vccd1 vccd1 sky130_fd_sc_hd__diode_2
X_3364_ _4546_/Q _3396_/A2 _3362_/X _3363_/X vssd1 vssd1 vccd1 vccd1 _4546_/D sky130_fd_sc_hd__a22o_1
X_2315_ _4075_/S _2323_/B vssd1 vssd1 vccd1 vccd1 _2315_/Y sky130_fd_sc_hd__nor2_1
X_3295_ _3295_/A _3447_/A _3295_/C _3295_/D vssd1 vssd1 vccd1 vccd1 _3295_/X sky130_fd_sc_hd__and4_1
X_2246_ hold6/X _4554_/Q _2249_/S vssd1 vssd1 vccd1 vccd1 _4425_/D sky130_fd_sc_hd__mux2_1
XFILLER_57_228 vssd1 vssd1 vccd1 vccd1 sky130_fd_sc_hd__fill_1
XFILLER_38_464 vssd1 vssd1 vccd1 vccd1 sky130_fd_sc_hd__decap_4
XANTENNA_fanout343_A _4320_/A vssd1 vssd1 vccd1 vccd1 sky130_fd_sc_hd__diode_2
XFILLER_25_169 vssd1 vssd1 vccd1 vccd1 sky130_fd_sc_hd__decap_3
XFILLER_40_139 vssd1 vssd1 vccd1 vccd1 sky130_fd_sc_hd__fill_1
XTAP_TAPCELL_ROW_51_646 vssd1 vccd1 sky130_fd_sc_hd__tapvpwrvgnd_1
XFILLER_21_364 vccd1 vssd1 vccd1 vssd1 sky130_ef_sc_hd__decap_12
X_4818_ _4818_/CLK _4818_/D fanout403/X vssd1 vssd1 vccd1 vccd1 _4818_/Q sky130_fd_sc_hd__dfrtp_1
XANTENNA_fanout229_X _4081_/A2 vssd1 vssd1 vccd1 vccd1 sky130_fd_sc_hd__diode_2
X_4749_ _4815_/CLK _4749_/D fanout394/X vssd1 vssd1 vccd1 vccd1 _4749_/Q sky130_fd_sc_hd__dfrtp_1
XANTENNA__2303__A _4063_/S vssd1 vssd1 vccd1 vccd1 sky130_fd_sc_hd__diode_2
Xoutput58 hold15/A vssd1 vssd1 vccd1 vccd1 m_axis_tdata[29] sky130_fd_sc_hd__buf_2
Xoutput47 hold32/A vssd1 vssd1 vccd1 vccd1 m_axis_tdata[19] sky130_fd_sc_hd__buf_2
Xoutput69 hold91/A vssd1 vssd1 vccd1 vccd1 m_axis_tdata[39] sky130_fd_sc_hd__buf_2
XFILLER_0_279 vssd1 vssd1 vccd1 vccd1 sky130_fd_sc_hd__fill_1
XTAP_TAPCELL_ROW_59_724 vssd1 vccd1 sky130_fd_sc_hd__tapvpwrvgnd_1
XFILLER_56_283 vssd1 vssd1 vccd1 vccd1 sky130_fd_sc_hd__fill_2
XTAP_TAPCELL_ROW_67_790 vssd1 vccd1 sky130_fd_sc_hd__tapvpwrvgnd_1
XFILLER_71_264 vssd1 vssd1 vccd1 vccd1 sky130_fd_sc_hd__decap_8
XFILLER_44_467 vssd1 vssd1 vccd1 vccd1 sky130_fd_sc_hd__decap_3
XTAP_TAPCELL_ROW_14_315 vssd1 vccd1 sky130_fd_sc_hd__tapvpwrvgnd_1
XFILLER_8_357 vssd1 vssd1 vccd1 vccd1 sky130_fd_sc_hd__decap_6
XANTENNA__3947__A2_N _3971_/A1 vssd1 vssd1 vccd1 vccd1 sky130_fd_sc_hd__diode_2
XANTENNA__2359__S _2365_/S vssd1 vssd1 vccd1 vccd1 sky130_fd_sc_hd__diode_2
X_3080_ _4767_/Q _4782_/Q _3150_/A _3064_/B vssd1 vssd1 vccd1 vccd1 _3087_/A sky130_fd_sc_hd__a31o_1
X_3982_ _3981_/D _4022_/A2 _3983_/B2 vssd1 vssd1 vccd1 vccd1 _3982_/Y sky130_fd_sc_hd__o21ai_1
X_2933_ _4764_/Q _4779_/Q vssd1 vssd1 vccd1 vccd1 _2934_/B sky130_fd_sc_hd__nor2_1
XANTENNA__4025__D _4087_/S vssd1 vssd1 vccd1 vccd1 sky130_fd_sc_hd__diode_2
X_2864_ _2864_/A _2864_/B vssd1 vssd1 vccd1 vccd1 _2864_/X sky130_fd_sc_hd__or2_1
X_2795_ _2795_/A _2795_/B vssd1 vssd1 vccd1 vccd1 _2795_/Y sky130_fd_sc_hd__xnor2_1
X_4603_ _4605_/CLK _4603_/D fanout426/X vssd1 vssd1 vccd1 vccd1 _4603_/Q sky130_fd_sc_hd__dfrtp_2
X_4534_ _4644_/CLK _4534_/D fanout428/X vssd1 vssd1 vccd1 vccd1 _4534_/Q sky130_fd_sc_hd__dfrtp_1
X_4465_ _4702_/CLK _4465_/D fanout386/X vssd1 vssd1 vccd1 vccd1 _4465_/Q sky130_fd_sc_hd__dfrtp_1
X_4396_ _3873_/A input11/X _4397_/S vssd1 vssd1 vccd1 vccd1 _4805_/D sky130_fd_sc_hd__mux2_1
X_3416_ _4555_/Q _4596_/Q _3226_/B _3412_/A vssd1 vssd1 vccd1 vccd1 _3416_/X sky130_fd_sc_hd__a211o_1
XANTENNA__2269__S _2270_/S vssd1 vssd1 vccd1 vccd1 sky130_fd_sc_hd__diode_2
X_3347_ _4584_/Q _3384_/A2 _3395_/B1 _3367_/C1 vssd1 vssd1 vccd1 vccd1 _3347_/X sky130_fd_sc_hd__o211a_1
X_3278_ _3273_/A _3273_/B _3359_/C _3276_/X vssd1 vssd1 vccd1 vccd1 _3278_/X sky130_fd_sc_hd__a31o_2
XANTENNA__4077__A2 _4105_/A2 vssd1 vssd1 vccd1 vccd1 sky130_fd_sc_hd__diode_2
XFILLER_26_412 vssd1 vssd1 vccd1 vccd1 sky130_fd_sc_hd__decap_3
X_2229_ _3925_/S _2229_/B vssd1 vssd1 vccd1 vccd1 _2229_/X sky130_fd_sc_hd__and2_1
XFILLER_41_437 vssd1 vssd1 vccd1 vccd1 sky130_fd_sc_hd__decap_8
XFILLER_41_459 vssd1 vssd1 vccd1 vccd1 sky130_fd_sc_hd__fill_1
XFILLER_5_327 vssd1 vssd1 vccd1 vccd1 sky130_fd_sc_hd__decap_8
XPHY_EDGE_ROW_39_Left_127 vssd1 vssd1 vccd1 vccd1 sky130_fd_sc_hd__decap_3
XFILLER_67_54 vssd1 vssd1 vccd1 vccd1 sky130_fd_sc_hd__fill_2
XANTENNA_input21_A s_axis_tdata[26] vssd1 vssd1 vccd1 vccd1 sky130_fd_sc_hd__diode_2
XPHY_EDGE_ROW_48_Left_136 vssd1 vssd1 vccd1 vccd1 sky130_fd_sc_hd__decap_3
XFILLER_29_294 vssd1 vssd1 vccd1 vccd1 sky130_fd_sc_hd__fill_1
XFILLER_17_478 vssd1 vssd1 vccd1 vccd1 sky130_fd_sc_hd__fill_2
XFILLER_44_275 vssd1 vssd1 vccd1 vccd1 sky130_fd_sc_hd__decap_6
XPHY_EDGE_ROW_57_Left_145 vssd1 vssd1 vccd1 vccd1 sky130_fd_sc_hd__decap_3
XANTENNA__3981__B _4001_/B vssd1 vssd1 vccd1 vccd1 sky130_fd_sc_hd__diode_2
X_2580_ _2580_/A _2580_/B _2580_/C vssd1 vssd1 vccd1 vccd1 _2582_/A sky130_fd_sc_hd__or3_1
X_4250_ _4286_/A_N _4282_/B _4270_/C _4313_/S vssd1 vssd1 vccd1 vccd1 _4250_/X sky130_fd_sc_hd__and4b_1
XFILLER_86_109 vccd1 vssd1 vccd1 vssd1 sky130_ef_sc_hd__decap_12
X_4181_ _4737_/Q _4240_/B1 _4178_/X _4180_/X vssd1 vssd1 vccd1 vccd1 _4737_/D sky130_fd_sc_hd__o22a_1
X_3201_ _3202_/A _3202_/B vssd1 vssd1 vccd1 vccd1 _3295_/C sky130_fd_sc_hd__nor2_1
X_3132_ _3151_/A _3132_/B _3132_/C vssd1 vssd1 vccd1 vccd1 _3133_/B sky130_fd_sc_hd__and3_1
XPHY_EDGE_ROW_66_Left_154 vssd1 vssd1 vccd1 vccd1 sky130_fd_sc_hd__decap_3
X_3063_ _3063_/A _3063_/B _3063_/C vssd1 vssd1 vccd1 vccd1 _3064_/B sky130_fd_sc_hd__and3_1
XTAP_TAPCELL_ROW_61_741 vssd1 vccd1 sky130_fd_sc_hd__tapvpwrvgnd_1
X_3965_ _4033_/D _3974_/A1 _4029_/D _3899_/Y vssd1 vssd1 vccd1 vccd1 _3965_/X sky130_fd_sc_hd__o2bb2a_1
X_3896_ _4818_/Q _3919_/B vssd1 vssd1 vccd1 vccd1 _3896_/X sky130_fd_sc_hd__and2_1
XPHY_EDGE_ROW_75_Left_163 vssd1 vssd1 vccd1 vccd1 sky130_fd_sc_hd__decap_3
XTAP_TAPCELL_ROW_33_487 vssd1 vccd1 sky130_fd_sc_hd__tapvpwrvgnd_1
X_2916_ _2916_/A _2916_/B vssd1 vssd1 vccd1 vccd1 _2916_/X sky130_fd_sc_hd__xor2_1
XFILLER_12_27 vssd1 vssd1 vccd1 vccd1 sky130_fd_sc_hd__fill_1
XANTENNA__3990__A1 _4119_/S vssd1 vssd1 vccd1 vccd1 sky130_fd_sc_hd__diode_2
XANTENNA__4052__B _4120_/D vssd1 vssd1 vccd1 vccd1 sky130_fd_sc_hd__diode_2
X_2847_ _2847_/A _2847_/B vssd1 vssd1 vccd1 vccd1 _2848_/B sky130_fd_sc_hd__nand2_1
XFILLER_12_49 vssd1 vssd1 vccd1 vccd1 sky130_fd_sc_hd__fill_1
Xhold110 _4722_/Q vssd1 vssd1 vccd1 vccd1 hold110/X sky130_fd_sc_hd__dlygate4sd3_1
XANTENNA_fanout306_A _4800_/Q vssd1 vssd1 vccd1 vccd1 sky130_fd_sc_hd__diode_2
X_2778_ _2775_/Y _2776_/X _2766_/X _2767_/Y vssd1 vssd1 vccd1 vccd1 _2780_/A sky130_fd_sc_hd__o211a_1
XANTENNA_clkbuf_2_1__f_clk_A clkbuf_0_clk/X vssd1 vssd1 vccd1 vccd1 sky130_fd_sc_hd__diode_2
Xhold143 _4688_/Q vssd1 vssd1 vccd1 vccd1 hold143/X sky130_fd_sc_hd__dlygate4sd3_1
XANTENNA_clkbuf_leaf_1_clk_A clkload0/A vssd1 vssd1 vccd1 vccd1 sky130_fd_sc_hd__diode_2
X_4517_ _4702_/CLK _4517_/D fanout410/X vssd1 vssd1 vccd1 vccd1 _4517_/Q sky130_fd_sc_hd__dfrtp_2
Xhold121 _4681_/Q vssd1 vssd1 vccd1 vccd1 hold121/X sky130_fd_sc_hd__dlygate4sd3_1
Xhold132 _4714_/Q vssd1 vssd1 vccd1 vccd1 hold132/X sky130_fd_sc_hd__dlygate4sd3_1
X_4448_ _4577_/CLK _4448_/D fanout437/X vssd1 vssd1 vccd1 vccd1 hold40/A sky130_fd_sc_hd__dfrtp_1
Xhold154 _4678_/Q vssd1 vssd1 vccd1 vccd1 hold154/X sky130_fd_sc_hd__dlygate4sd3_1
Xhold165 _4756_/Q vssd1 vssd1 vccd1 vccd1 hold165/X sky130_fd_sc_hd__dlygate4sd3_1
Xhold176 _4718_/Q vssd1 vssd1 vccd1 vccd1 hold176/X sky130_fd_sc_hd__dlygate4sd3_1
Xhold198 _4676_/Q vssd1 vssd1 vccd1 vccd1 hold198/X sky130_fd_sc_hd__dlygate4sd3_1
Xhold187 _4625_/Q vssd1 vssd1 vccd1 vccd1 hold187/X sky130_fd_sc_hd__dlygate4sd3_1
XPHY_EDGE_ROW_84_Left_172 vssd1 vssd1 vccd1 vccd1 sky130_fd_sc_hd__decap_3
X_4379_ _4116_/B input3/X _4400_/S vssd1 vssd1 vccd1 vccd1 _4788_/D sky130_fd_sc_hd__mux2_1
XFILLER_73_337 vssd1 vssd1 vccd1 vccd1 sky130_fd_sc_hd__fill_1
XFILLER_41_267 vccd1 vssd1 vccd1 vssd1 sky130_ef_sc_hd__decap_12
XFILLER_5_113 vssd1 vssd1 vccd1 vccd1 sky130_fd_sc_hd__decap_4
XANTENNA__4389__S _4408_/S vssd1 vssd1 vccd1 vccd1 sky130_fd_sc_hd__diode_2
XFILLER_49_334 vssd1 vssd1 vccd1 vccd1 sky130_fd_sc_hd__fill_2
XFILLER_64_315 vssd1 vssd1 vccd1 vccd1 sky130_fd_sc_hd__fill_2
XFILLER_76_197 vccd1 vssd1 vccd1 vssd1 sky130_ef_sc_hd__decap_12
XFILLER_76_186 vssd1 vssd1 vccd1 vccd1 sky130_fd_sc_hd__decap_8
XTAP_TAPCELL_ROW_75_866 vssd1 vccd1 sky130_fd_sc_hd__tapvpwrvgnd_1
XFILLER_17_242 vssd1 vssd1 vccd1 vccd1 sky130_fd_sc_hd__fill_2
XFILLER_17_264 vssd1 vssd1 vccd1 vccd1 sky130_fd_sc_hd__fill_2
X_3750_ _4608_/Q _3735_/S _3749_/X _3748_/Y vssd1 vssd1 vccd1 vccd1 _4608_/D sky130_fd_sc_hd__a22o_1
XFILLER_20_429 vssd1 vssd1 vccd1 vccd1 sky130_fd_sc_hd__fill_2
XANTENNA__3972__A1 _4037_/D vssd1 vssd1 vccd1 vccd1 sky130_fd_sc_hd__diode_2
X_2701_ _4697_/Q _4684_/Q vssd1 vssd1 vccd1 vccd1 _2701_/Y sky130_fd_sc_hd__nor2_1
XTAP_TAPCELL_ROW_30_457 vssd1 vccd1 sky130_fd_sc_hd__tapvpwrvgnd_1
X_3681_ _3679_/B _3685_/A _3674_/A vssd1 vssd1 vccd1 vccd1 _3683_/A sky130_fd_sc_hd__a21oi_1
X_2632_ _2632_/A _2632_/B _2632_/C vssd1 vssd1 vccd1 vccd1 _2688_/A sky130_fd_sc_hd__nand3_2
X_2563_ _2563_/A _2563_/B vssd1 vssd1 vccd1 vccd1 _3815_/B sky130_fd_sc_hd__nand2_1
X_4302_ _4245_/D _4306_/B _4302_/C _4302_/D vssd1 vssd1 vccd1 vccd1 _4302_/X sky130_fd_sc_hd__and4b_1
X_4233_ _4232_/Y _4231_/X _4230_/X hold184/X _4240_/B1 vssd1 vssd1 vccd1 vccd1 _4750_/D
+ sky130_fd_sc_hd__o32a_1
XFILLER_4_190 vssd1 vssd1 vccd1 vccd1 sky130_fd_sc_hd__decap_6
XFILLER_4_61 vssd1 vssd1 vccd1 vccd1 sky130_fd_sc_hd__fill_1
X_2494_ _4690_/Q _4677_/Q vssd1 vssd1 vccd1 vccd1 _2496_/B sky130_fd_sc_hd__xor2_1
XFILLER_87_429 vssd1 vssd1 vccd1 vccd1 sky130_fd_sc_hd__fill_1
X_4164_ _4231_/D _4175_/B _4168_/C _4231_/C vssd1 vssd1 vccd1 vccd1 _4164_/X sky130_fd_sc_hd__and4b_1
X_3115_ _3089_/A _3089_/C _3101_/X _3102_/X _3086_/X vssd1 vssd1 vccd1 vccd1 _3115_/Y
+ sky130_fd_sc_hd__a221oi_2
XANTENNA__4328__A _4328_/A vssd1 vssd1 vccd1 vccd1 sky130_fd_sc_hd__diode_2
X_4095_ _4103_/A0 _4103_/A1 _4302_/D vssd1 vssd1 vccd1 vccd1 _4095_/X sky130_fd_sc_hd__mux2_1
X_3046_ _3144_/A _3046_/B vssd1 vssd1 vccd1 vccd1 _3053_/A sky130_fd_sc_hd__xnor2_1
XTAP_TAPCELL_ROW_38_535 vssd1 vccd1 sky130_fd_sc_hd__tapvpwrvgnd_1
XFILLER_55_326 vssd1 vssd1 vccd1 vccd1 sky130_fd_sc_hd__decap_8
XFILLER_70_307 vssd1 vssd1 vccd1 vccd1 sky130_fd_sc_hd__fill_1
XFILLER_23_223 vssd1 vssd1 vccd1 vccd1 sky130_fd_sc_hd__fill_1
XANTENNA_fanout423_A fanout424/X vssd1 vssd1 vccd1 vccd1 sky130_fd_sc_hd__diode_2
XANTENNA__4204__A2 _4212_/A2 vssd1 vssd1 vccd1 vccd1 sky130_fd_sc_hd__diode_2
X_3948_ _2311_/A _3873_/Y _3947_/X _3999_/B2 vssd1 vssd1 vccd1 vccd1 _3948_/X sky130_fd_sc_hd__o211a_1
X_3879_ _4020_/A0 _4652_/Q _3928_/S vssd1 vssd1 vccd1 vccd1 _4652_/D sky130_fd_sc_hd__mux2_1
XANTENNA_fanout309_X _4360_/A vssd1 vssd1 vccd1 vccd1 sky130_fd_sc_hd__diode_2
XFILLER_2_138 vssd1 vssd1 vccd1 vccd1 sky130_fd_sc_hd__fill_2
XANTENNA__2311__A _2311_/A vssd1 vssd1 vccd1 vccd1 sky130_fd_sc_hd__diode_2
XFILLER_78_418 vssd1 vssd1 vccd1 vccd1 sky130_fd_sc_hd__fill_2
Xfanout420 fanout422/X vssd1 vssd1 vccd1 vccd1 fanout420/X sky130_fd_sc_hd__buf_1
Xfanout431 fanout434/X vssd1 vssd1 vccd1 vccd1 _3923_/C sky130_fd_sc_hd__buf_2
XFILLER_58_153 vccd1 vssd1 vccd1 vssd1 sky130_ef_sc_hd__decap_12
XFILLER_64_33 vssd1 vssd1 vccd1 vccd1 sky130_fd_sc_hd__fill_1
XTAP_TAPCELL_ROW_72_836 vssd1 vccd1 sky130_fd_sc_hd__tapvpwrvgnd_1
XFILLER_14_267 vssd1 vssd1 vccd1 vccd1 sky130_fd_sc_hd__fill_2
Xfanout82 _3460_/A1 vssd1 vssd1 vccd1 vccd1 _3507_/A sky130_fd_sc_hd__clkbuf_2
Xfanout93 _4410_/S vssd1 vssd1 vccd1 vccd1 _4406_/S sky130_fd_sc_hd__clkbuf_2
XFILLER_80_87 vssd1 vssd1 vccd1 vccd1 sky130_fd_sc_hd__decap_4
XFILLER_6_400 vssd1 vssd1 vccd1 vccd1 sky130_fd_sc_hd__decap_3
XFILLER_10_473 vssd1 vssd1 vccd1 vccd1 sky130_fd_sc_hd__decap_3
XFILLER_6_477 vccd1 vssd1 vccd1 vssd1 sky130_ef_sc_hd__decap_12
XTAP_TAPCELL_ROW_9_271 vssd1 vccd1 sky130_fd_sc_hd__tapvpwrvgnd_1
XANTENNA__4131__A1 _4171_/A1 vssd1 vssd1 vccd1 vccd1 sky130_fd_sc_hd__diode_2
XANTENNA__2367__S _2369_/S vssd1 vssd1 vccd1 vccd1 sky130_fd_sc_hd__diode_2
XFILLER_49_164 vssd1 vssd1 vccd1 vccd1 sky130_fd_sc_hd__decap_4
XFILLER_77_495 vssd1 vssd1 vccd1 vccd1 sky130_fd_sc_hd__fill_1
XANTENNA__3890__A0 _4214_/A0 vssd1 vssd1 vccd1 vccd1 sky130_fd_sc_hd__diode_2
XTAP_TAPCELL_ROW_35_505 vssd1 vccd1 sky130_fd_sc_hd__tapvpwrvgnd_1
X_3802_ _4619_/Q _3795_/S _3801_/Y vssd1 vssd1 vccd1 vccd1 _4619_/D sky130_fd_sc_hd__a21o_1
XANTENNA__4198__A1 _4210_/A1 vssd1 vssd1 vccd1 vccd1 sky130_fd_sc_hd__diode_2
X_4782_ _4782_/CLK _4782_/D fanout402/X vssd1 vssd1 vccd1 vccd1 _4782_/Q sky130_fd_sc_hd__dfrtp_1
X_3733_ _3664_/A _3726_/Y _3732_/X vssd1 vssd1 vccd1 vccd1 _3734_/B sky130_fd_sc_hd__a21oi_2
X_3664_ _3664_/A _3690_/A vssd1 vssd1 vccd1 vccd1 _3664_/Y sky130_fd_sc_hd__xnor2_1
Xclkload41 _4647_/CLK vssd1 vssd1 vccd1 vccd1 clkload41/Y sky130_fd_sc_hd__inv_6
X_2615_ _2615_/A _2615_/B vssd1 vssd1 vccd1 vccd1 _2615_/Y sky130_fd_sc_hd__xnor2_1
Xclkload30 _4820_/CLK vssd1 vssd1 vccd1 vccd1 clkload30/X sky130_fd_sc_hd__clkbuf_8
X_3595_ _3587_/A _3590_/Y _3594_/X vssd1 vssd1 vccd1 vccd1 _3595_/Y sky130_fd_sc_hd__o21ai_1
X_2546_ _2545_/Y _4460_/Q _2588_/C vssd1 vssd1 vccd1 vccd1 _2549_/A sky130_fd_sc_hd__and3b_1
X_2477_ _4689_/Q _4676_/Q vssd1 vssd1 vccd1 vccd1 _2479_/B sky130_fd_sc_hd__xor2_1
XFILLER_87_237 vccd1 vssd1 vccd1 vssd1 sky130_ef_sc_hd__decap_12
XFILLER_68_440 vccd1 vssd1 vccd1 vssd1 sky130_ef_sc_hd__decap_12
X_4216_ _4215_/C _4240_/A2 _4224_/B1 vssd1 vssd1 vccd1 vccd1 _4216_/Y sky130_fd_sc_hd__o21ai_1
XFILLER_68_462 vccd1 vssd1 vccd1 vssd1 sky130_ef_sc_hd__decap_12
X_4147_ _4171_/A0 _4167_/A1 _4352_/A vssd1 vssd1 vccd1 vccd1 _4147_/X sky130_fd_sc_hd__mux2_1
XFILLER_83_432 vssd1 vssd1 vccd1 vccd1 sky130_fd_sc_hd__fill_1
XFILLER_83_454 vccd1 vssd1 vccd1 vssd1 sky130_ef_sc_hd__decap_12
X_4078_ _4077_/Y _4076_/X _4075_/X hold113/X _4193_/B2 vssd1 vssd1 vccd1 vccd1 _4711_/D
+ sky130_fd_sc_hd__o32a_1
XFILLER_55_167 vssd1 vssd1 vccd1 vccd1 sky130_fd_sc_hd__fill_1
XFILLER_70_104 vccd1 vssd1 vccd1 vssd1 sky130_ef_sc_hd__decap_12
X_3029_ _3027_/Y _3029_/B vssd1 vssd1 vccd1 vccd1 _3029_/Y sky130_fd_sc_hd__nand2b_1
XANTENNA_fanout161_X _4338_/A2 vssd1 vssd1 vccd1 vccd1 sky130_fd_sc_hd__diode_2
XANTENNA_fanout259_X _4258_/C vssd1 vssd1 vccd1 vccd1 sky130_fd_sc_hd__diode_2
Xclkload2 clkload2/A vssd1 vssd1 vccd1 vccd1 clkload2/Y sky130_fd_sc_hd__clkinvlp_4
XANTENNA__4361__A1 _4360_/A vssd1 vssd1 vccd1 vccd1 sky130_fd_sc_hd__diode_2
XFILLER_59_55 vssd1 vssd1 vccd1 vccd1 sky130_fd_sc_hd__fill_1
Xfanout250 _2224_/Y vssd1 vssd1 vccd1 vccd1 _4328_/C sky130_fd_sc_hd__buf_2
XFILLER_78_237 vccd1 vssd1 vccd1 vssd1 sky130_ef_sc_hd__decap_12
XTAP_TAPCELL_ROW_6_241 vssd1 vccd1 sky130_fd_sc_hd__tapvpwrvgnd_1
Xfanout261 _4243_/A2 vssd1 vssd1 vccd1 vccd1 _4178_/D sky130_fd_sc_hd__clkbuf_2
Xfanout283 _4064_/C vssd1 vssd1 vccd1 vccd1 _4056_/D sky130_fd_sc_hd__clkbuf_2
Xfanout272 _4812_/Q vssd1 vssd1 vccd1 vccd1 _4136_/B sky130_fd_sc_hd__clkbuf_2
XFILLER_75_43 vssd1 vssd1 vccd1 vccd1 sky130_fd_sc_hd__decap_3
Xfanout294 _4805_/Q vssd1 vssd1 vccd1 vccd1 _3873_/A sky130_fd_sc_hd__buf_2
XFILLER_19_337 vssd1 vssd1 vccd1 vccd1 sky130_fd_sc_hd__decap_3
XFILLER_46_101 vssd1 vssd1 vccd1 vccd1 sky130_fd_sc_hd__fill_1
XFILLER_46_123 vssd1 vssd1 vccd1 vccd1 sky130_fd_sc_hd__fill_2
XTAP_TAPCELL_ROW_85_950 vssd1 vccd1 sky130_fd_sc_hd__tapvpwrvgnd_1
XANTENNA__3927__A1 _3971_/A1 vssd1 vssd1 vccd1 vccd1 sky130_fd_sc_hd__diode_2
XTAP_TAPCELL_ROW_40_552 vssd1 vccd1 sky130_fd_sc_hd__tapvpwrvgnd_1
XTAP_TAPCELL_ROW_12_298 vssd1 vccd1 sky130_fd_sc_hd__tapvpwrvgnd_1
XFILLER_6_241 vssd1 vssd1 vccd1 vccd1 sky130_fd_sc_hd__decap_4
X_2400_ hold49/X _2399_/X _2424_/S vssd1 vssd1 vccd1 vccd1 _4495_/D sky130_fd_sc_hd__mux2_1
X_3380_ _3380_/A _3380_/B _3380_/C vssd1 vssd1 vccd1 vccd1 _3382_/A sky130_fd_sc_hd__and3_1
X_2331_ _4029_/D _2338_/B vssd1 vssd1 vccd1 vccd1 _2331_/Y sky130_fd_sc_hd__nor2_1
X_2262_ hold60/X _4570_/Q _2270_/S vssd1 vssd1 vccd1 vccd1 _4441_/D sky130_fd_sc_hd__mux2_1
XFILLER_69_237 vssd1 vssd1 vccd1 vccd1 sky130_fd_sc_hd__fill_2
XANTENNA_clkbuf_leaf_41_clk_A clkload2/A vssd1 vssd1 vccd1 vccd1 sky130_fd_sc_hd__diode_2
X_4001_ _4056_/D _4001_/B _4001_/C _4063_/S vssd1 vssd1 vccd1 vccd1 _4001_/X sky130_fd_sc_hd__and4b_1
XFILLER_27_3 vccd1 vssd1 vccd1 vssd1 sky130_ef_sc_hd__decap_12
XFILLER_77_281 vccd1 vssd1 vccd1 vssd1 sky130_ef_sc_hd__decap_12
XFILLER_37_167 vssd1 vssd1 vccd1 vccd1 sky130_fd_sc_hd__fill_1
X_4765_ _4782_/CLK _4765_/D fanout396/X vssd1 vssd1 vccd1 vccd1 _4765_/Q sky130_fd_sc_hd__dfrtp_2
XANTENNA_fanout121_A _2427_/X vssd1 vssd1 vccd1 vccd1 sky130_fd_sc_hd__diode_2
X_3716_ _3716_/A _3716_/B vssd1 vssd1 vccd1 vccd1 _3716_/Y sky130_fd_sc_hd__nor2_1
X_4696_ clkload7/A _4696_/D fanout381/X vssd1 vssd1 vccd1 vccd1 _4696_/Q sky130_fd_sc_hd__dfrtp_1
XFILLER_20_27 vssd1 vssd1 vccd1 vccd1 sky130_fd_sc_hd__fill_1
XANTENNA__4060__B _4104_/B vssd1 vssd1 vccd1 vccd1 sky130_fd_sc_hd__diode_2
X_3647_ _3647_/A _3647_/B vssd1 vssd1 vccd1 vccd1 _3656_/B sky130_fd_sc_hd__nor2_1
X_3578_ _3578_/A _3578_/B vssd1 vssd1 vccd1 vccd1 _3579_/B sky130_fd_sc_hd__nand2_1
X_2529_ _2560_/A _2529_/B vssd1 vssd1 vccd1 vccd1 _2531_/B sky130_fd_sc_hd__or2_1
Xhold14 hold14/A vssd1 vssd1 vccd1 vccd1 hold14/X sky130_fd_sc_hd__dlygate4sd3_1
Xhold47 hold47/A vssd1 vssd1 vccd1 vccd1 hold47/X sky130_fd_sc_hd__dlygate4sd3_1
XFILLER_75_207 vccd1 vssd1 vccd1 vssd1 sky130_ef_sc_hd__decap_12
Xhold25 hold25/A vssd1 vssd1 vccd1 vccd1 hold25/X sky130_fd_sc_hd__dlygate4sd3_1
Xhold36 hold36/A vssd1 vssd1 vccd1 vccd1 hold36/X sky130_fd_sc_hd__dlygate4sd3_1
Xhold69 hold69/A vssd1 vssd1 vccd1 vccd1 hold69/X sky130_fd_sc_hd__dlygate4sd3_1
Xhold58 hold58/A vssd1 vssd1 vccd1 vccd1 hold58/X sky130_fd_sc_hd__dlygate4sd3_1
XANTENNA__4219__C _4219_/C vssd1 vssd1 vccd1 vccd1 sky130_fd_sc_hd__diode_2
XFILLER_28_156 vccd1 vssd1 vccd1 vssd1 sky130_ef_sc_hd__decap_12
XFILLER_16_329 vssd1 vssd1 vccd1 vccd1 sky130_fd_sc_hd__fill_1
XTAP_TAPCELL_ROW_82_931 vssd1 vccd1 sky130_fd_sc_hd__tapvpwrvgnd_1
XFILLER_71_457 vssd1 vssd1 vccd1 vccd1 sky130_fd_sc_hd__fill_1
XFILLER_43_148 vccd1 vssd1 vccd1 vssd1 sky130_ef_sc_hd__decap_12
XTAP_TAPCELL_ROW_54_677 vssd1 vccd1 sky130_fd_sc_hd__tapvpwrvgnd_1
XPHY_EDGE_ROW_20_Left_108 vssd1 vssd1 vccd1 vccd1 sky130_fd_sc_hd__decap_3
XANTENNA__4397__S _4397_/S vssd1 vssd1 vccd1 vccd1 sky130_fd_sc_hd__diode_2
XFILLER_86_53 vccd1 vssd1 vccd1 vssd1 sky130_ef_sc_hd__decap_12
XFILLER_86_97 vccd1 vssd1 vccd1 vssd1 sky130_ef_sc_hd__decap_12
XFILLER_59_281 vssd1 vssd1 vccd1 vccd1 sky130_fd_sc_hd__fill_1
XFILLER_47_443 vssd1 vssd1 vccd1 vccd1 sky130_fd_sc_hd__decap_4
XFILLER_74_251 vssd1 vssd1 vccd1 vccd1 sky130_fd_sc_hd__fill_1
XFILLER_34_104 vccd1 vssd1 vccd1 vssd1 sky130_ef_sc_hd__decap_12
XTAP_TAPCELL_ROW_17_346 vssd1 vccd1 sky130_fd_sc_hd__tapvpwrvgnd_1
XFILLER_70_490 vssd1 vssd1 vccd1 vccd1 sky130_fd_sc_hd__fill_1
X_2880_ _2880_/A _2880_/B _2880_/C vssd1 vssd1 vccd1 vccd1 _2883_/C sky130_fd_sc_hd__or3_1
X_4550_ _4587_/CLK _4550_/D fanout416/X vssd1 vssd1 vccd1 vccd1 _4550_/Q sky130_fd_sc_hd__dfrtp_1
X_3501_ _4612_/Q _3503_/A2 _3504_/B1 _3543_/A vssd1 vssd1 vccd1 vccd1 _3501_/X sky130_fd_sc_hd__o211a_1
X_4481_ _4820_/CLK _4481_/D fanout420/X vssd1 vssd1 vccd1 vccd1 hold2/A sky130_fd_sc_hd__dfrtp_1
X_3432_ _3432_/A _3432_/B vssd1 vssd1 vccd1 vccd1 _3432_/X sky130_fd_sc_hd__xor2_1
XANTENNA__4325__A1 _4253_/S vssd1 vssd1 vccd1 vccd1 sky130_fd_sc_hd__diode_2
X_3363_ _4587_/Q _3384_/A2 _3395_/B1 _3367_/C1 vssd1 vssd1 vccd1 vccd1 _3363_/X sky130_fd_sc_hd__o211a_1
XANTENNA__2887__A1 _2857_/A vssd1 vssd1 vccd1 vccd1 sky130_fd_sc_hd__diode_2
XFILLER_85_505 vccd1 vssd1 vccd1 vssd1 sky130_ef_sc_hd__decap_12
X_2314_ _2341_/A0 _2341_/A1 _4017_/D vssd1 vssd1 vccd1 vccd1 _2314_/X sky130_fd_sc_hd__mux2_1
X_3294_ _3294_/A _3294_/B vssd1 vssd1 vccd1 vccd1 _3295_/D sky130_fd_sc_hd__nor2_1
X_2245_ hold51/X _4553_/Q _2249_/S vssd1 vssd1 vccd1 vccd1 _4424_/D sky130_fd_sc_hd__mux2_1
XFILLER_38_421 vccd1 vssd1 vccd1 vssd1 sky130_ef_sc_hd__decap_12
XPHY_EDGE_ROW_11_Left_99 vssd1 vssd1 vccd1 vccd1 sky130_fd_sc_hd__decap_3
XANTENNA__3878__C _3976_/D vssd1 vssd1 vccd1 vccd1 sky130_fd_sc_hd__diode_2
XANTENNA_fanout336_A _4328_/A vssd1 vssd1 vccd1 vccd1 sky130_fd_sc_hd__diode_2
XTAP_TAPCELL_ROW_51_647 vssd1 vccd1 sky130_fd_sc_hd__tapvpwrvgnd_1
X_4817_ _4817_/CLK _4817_/D fanout397/X vssd1 vssd1 vccd1 vccd1 _4817_/Q sky130_fd_sc_hd__dfrtp_1
XFILLER_33_192 vssd1 vssd1 vccd1 vccd1 sky130_fd_sc_hd__fill_2
XANTENNA__2290__S _4123_/S vssd1 vssd1 vccd1 vccd1 sky130_fd_sc_hd__diode_2
XFILLER_21_376 vccd1 vssd1 vccd1 vssd1 sky130_ef_sc_hd__decap_12
XFILLER_31_26 vssd1 vssd1 vccd1 vccd1 sky130_fd_sc_hd__fill_1
X_4748_ _4748_/CLK _4748_/D fanout390/X vssd1 vssd1 vccd1 vccd1 _4748_/Q sky130_fd_sc_hd__dfrtp_1
XANTENNA_fanout124_X _3928_/S vssd1 vssd1 vccd1 vccd1 sky130_fd_sc_hd__diode_2
XFILLER_31_48 vssd1 vssd1 vccd1 vccd1 sky130_fd_sc_hd__decap_8
XANTENNA__2303__B _2323_/B vssd1 vssd1 vccd1 vccd1 sky130_fd_sc_hd__diode_2
X_4679_ clkload4/A _4679_/D fanout376/X vssd1 vssd1 vccd1 vccd1 _4679_/Q sky130_fd_sc_hd__dfrtp_1
XPHY_EDGE_ROW_1_Right_1 vssd1 vssd1 vccd1 vccd1 sky130_fd_sc_hd__decap_3
Xoutput37 hold24/A vssd1 vssd1 vccd1 vccd1 m_axis_tdata[0] sky130_fd_sc_hd__buf_2
Xoutput48 hold22/A vssd1 vssd1 vccd1 vccd1 m_axis_tdata[1] sky130_fd_sc_hd__buf_2
XFILLER_0_225 vccd1 vssd1 vccd1 vssd1 sky130_ef_sc_hd__decap_12
Xoutput59 hold48/A vssd1 vssd1 vccd1 vccd1 m_axis_tdata[2] sky130_fd_sc_hd__buf_2
XFILLER_56_240 vssd1 vssd1 vccd1 vccd1 sky130_fd_sc_hd__fill_1
XFILLER_56_251 vssd1 vssd1 vccd1 vccd1 sky130_fd_sc_hd__fill_1
XTAP_TAPCELL_ROW_67_791 vssd1 vccd1 sky130_fd_sc_hd__tapvpwrvgnd_1
XTAP_TAPCELL_ROW_14_316 vssd1 vccd1 sky130_fd_sc_hd__tapvpwrvgnd_1
XFILLER_31_129 vssd1 vssd1 vccd1 vccd1 sky130_fd_sc_hd__decap_4
Xclkbuf_leaf_51_clk clkload0/A vssd1 vssd1 vccd1 vccd1 _4794_/CLK sky130_fd_sc_hd__clkbuf_8
XANTENNA__4004__A0 _4020_/A0 vssd1 vssd1 vccd1 vccd1 sky130_fd_sc_hd__diode_2
XFILLER_8_347 vssd1 vssd1 vccd1 vccd1 sky130_fd_sc_hd__decap_8
XANTENNA__3530__A2 _3534_/A2 vssd1 vssd1 vccd1 vccd1 sky130_fd_sc_hd__diode_2
XFILLER_11_6 vssd1 vssd1 vccd1 vccd1 sky130_fd_sc_hd__fill_1
XFILLER_35_435 vssd1 vssd1 vccd1 vccd1 sky130_fd_sc_hd__decap_3
XFILLER_47_295 vssd1 vssd1 vccd1 vccd1 sky130_fd_sc_hd__fill_1
XANTENNA__4243__B1 _4361_/B1 vssd1 vssd1 vccd1 vccd1 sky130_fd_sc_hd__diode_2
X_3981_ _3976_/D _4001_/B _4001_/C _3981_/D vssd1 vssd1 vccd1 vccd1 _3981_/X sky130_fd_sc_hd__and4b_1
X_2932_ _4764_/Q _4779_/Q vssd1 vssd1 vccd1 vccd1 _2975_/B sky130_fd_sc_hd__and2_1
XFILLER_22_129 vssd1 vssd1 vccd1 vccd1 sky130_fd_sc_hd__fill_1
Xclkbuf_leaf_42_clk clkload2/A vssd1 vssd1 vccd1 vccd1 _4624_/CLK sky130_fd_sc_hd__clkbuf_8
X_2863_ _2861_/B _2861_/C _2861_/A vssd1 vssd1 vccd1 vccd1 _2864_/B sky130_fd_sc_hd__a21oi_1
X_2794_ _2792_/Y _2794_/B vssd1 vssd1 vccd1 vccd1 _2795_/B sky130_fd_sc_hd__nand2b_1
X_4602_ _4635_/CLK _4602_/D fanout426/X vssd1 vssd1 vccd1 vccd1 _4602_/Q sky130_fd_sc_hd__dfrtp_1
X_4533_ _4644_/CLK _4533_/D fanout428/X vssd1 vssd1 vccd1 vccd1 _4533_/Q sky130_fd_sc_hd__dfrtp_1
X_4464_ clkload8/A _4464_/D fanout381/X vssd1 vssd1 vccd1 vccd1 _4464_/Q sky130_fd_sc_hd__dfrtp_1
X_4395_ _4804_/Q input10/X _4397_/S vssd1 vssd1 vccd1 vccd1 _4804_/D sky130_fd_sc_hd__mux2_1
X_3415_ _4555_/Q _3425_/A2 _3413_/X _3414_/X vssd1 vssd1 vccd1 vccd1 _4555_/D sky130_fd_sc_hd__a22o_1
X_3346_ _3383_/A1 _3345_/Y _3383_/B1 vssd1 vssd1 vccd1 vccd1 _3346_/X sky130_fd_sc_hd__a21o_1
XFILLER_85_335 vssd1 vssd1 vccd1 vccd1 sky130_fd_sc_hd__fill_1
X_3277_ _3273_/A _3273_/B _3359_/C _3276_/X vssd1 vssd1 vccd1 vccd1 _3277_/Y sky130_fd_sc_hd__a31oi_2
XANTENNA_fanout286_A _4104_/C vssd1 vssd1 vccd1 vccd1 sky130_fd_sc_hd__diode_2
XFILLER_26_15 vssd1 vssd1 vccd1 vccd1 sky130_fd_sc_hd__decap_4
X_2228_ _4581_/Q _2369_/S vssd1 vssd1 vccd1 vccd1 _2228_/Y sky130_fd_sc_hd__nand2_1
XFILLER_38_262 vssd1 vssd1 vccd1 vccd1 sky130_fd_sc_hd__fill_1
XTAP_TAPCELL_ROW_64_761 vssd1 vccd1 sky130_fd_sc_hd__tapvpwrvgnd_1
XFILLER_26_457 vssd1 vssd1 vccd1 vccd1 sky130_fd_sc_hd__decap_3
XFILLER_53_265 vssd1 vssd1 vccd1 vccd1 sky130_fd_sc_hd__decap_4
XANTENNA_fanout241_X _2250_/S vssd1 vssd1 vccd1 vccd1 sky130_fd_sc_hd__diode_2
XFILLER_41_449 vssd1 vssd1 vccd1 vccd1 sky130_fd_sc_hd__fill_1
Xclkbuf_leaf_33_clk clkload2/A vssd1 vssd1 vccd1 vccd1 _4667_/CLK sky130_fd_sc_hd__clkbuf_8
XANTENNA__2796__B1 _3870_/B1 vssd1 vssd1 vccd1 vccd1 sky130_fd_sc_hd__diode_2
XFILLER_1_501 vssd1 vssd1 vccd1 vccd1 sky130_fd_sc_hd__decap_3
XFILLER_67_33 vssd1 vssd1 vccd1 vccd1 sky130_fd_sc_hd__decap_8
XANTENNA_input14_A s_axis_tdata[1] vssd1 vssd1 vccd1 vccd1 sky130_fd_sc_hd__diode_2
XFILLER_44_221 vssd1 vssd1 vccd1 vccd1 sky130_fd_sc_hd__decap_3
XTAP_TAPCELL_ROW_27_430 vssd1 vccd1 sky130_fd_sc_hd__tapvpwrvgnd_1
XFILLER_32_405 vccd1 vssd1 vccd1 vssd1 sky130_ef_sc_hd__decap_12
Xclkbuf_leaf_24_clk clkbuf_2_3__f_clk/X vssd1 vssd1 vccd1 vccd1 _4613_/CLK sky130_fd_sc_hd__clkbuf_8
XANTENNA__3981__C _4001_/C vssd1 vssd1 vccd1 vccd1 sky130_fd_sc_hd__diode_2
XFILLER_4_361 vssd1 vssd1 vccd1 vccd1 sky130_fd_sc_hd__decap_3
X_4180_ _4313_/S _4210_/A1 _4361_/B1 vssd1 vssd1 vccd1 vccd1 _4180_/X sky130_fd_sc_hd__a21o_1
X_3200_ _4561_/Q _4602_/Q vssd1 vssd1 vccd1 vccd1 _3202_/B sky130_fd_sc_hd__nor2_1
X_3131_ _3132_/B _3132_/C _3151_/A vssd1 vssd1 vccd1 vccd1 _3133_/A sky130_fd_sc_hd__a21oi_1
XFILLER_67_346 vssd1 vssd1 vccd1 vccd1 sky130_fd_sc_hd__decap_6
X_3062_ _3063_/B _3063_/C _3063_/A vssd1 vssd1 vccd1 vccd1 _3064_/A sky130_fd_sc_hd__a21oi_1
XANTENNA__2475__C1 _4666_/Q vssd1 vssd1 vccd1 vccd1 sky130_fd_sc_hd__diode_2
Xclkbuf_leaf_15_clk clkload1/A vssd1 vssd1 vccd1 vccd1 _4818_/CLK sky130_fd_sc_hd__clkbuf_8
XTAP_TAPCELL_ROW_61_742 vssd1 vccd1 sky130_fd_sc_hd__tapvpwrvgnd_1
X_3964_ hold121/X _4038_/B1 _3963_/X vssd1 vssd1 vccd1 vccd1 _4681_/D sky130_fd_sc_hd__o21ba_1
X_3895_ _4818_/Q _3919_/B vssd1 vssd1 vccd1 vccd1 _4373_/B sky130_fd_sc_hd__nor2_1
XTAP_TAPCELL_ROW_33_488 vssd1 vccd1 sky130_fd_sc_hd__tapvpwrvgnd_1
X_2915_ _2916_/B _2916_/A vssd1 vssd1 vccd1 vccd1 _2915_/X sky130_fd_sc_hd__and2b_1
XANTENNA__3990__A2 _4022_/A2 vssd1 vssd1 vccd1 vccd1 sky130_fd_sc_hd__diode_2
X_2846_ _2845_/C _2845_/A _2845_/B vssd1 vssd1 vccd1 vccd1 _2847_/B sky130_fd_sc_hd__o21ai_2
Xhold100 _4742_/Q vssd1 vssd1 vccd1 vccd1 hold100/X sky130_fd_sc_hd__dlygate4sd3_1
X_2777_ _2775_/A _2775_/B _2775_/C _2775_/D vssd1 vssd1 vccd1 vccd1 _2777_/Y sky130_fd_sc_hd__o22ai_1
Xhold133 _4623_/Q vssd1 vssd1 vccd1 vccd1 hold133/X sky130_fd_sc_hd__dlygate4sd3_1
Xhold111 _4662_/Q vssd1 vssd1 vccd1 vccd1 hold111/X sky130_fd_sc_hd__dlygate4sd3_1
X_4516_ _4624_/CLK _4516_/D fanout407/X vssd1 vssd1 vccd1 vccd1 _4516_/Q sky130_fd_sc_hd__dfrtp_1
Xhold122 _4461_/Q vssd1 vssd1 vccd1 vccd1 hold122/X sky130_fd_sc_hd__dlygate4sd3_1
Xhold144 _4744_/Q vssd1 vssd1 vccd1 vccd1 hold144/X sky130_fd_sc_hd__dlygate4sd3_1
Xhold166 _4787_/Q vssd1 vssd1 vccd1 vccd1 hold166/X sky130_fd_sc_hd__dlygate4sd3_1
X_4447_ _4576_/CLK _4447_/D fanout438/X vssd1 vssd1 vccd1 vccd1 hold47/A sky130_fd_sc_hd__dfrtp_1
Xhold155 _4521_/Q vssd1 vssd1 vccd1 vccd1 hold155/X sky130_fd_sc_hd__dlygate4sd3_1
Xhold177 _4738_/Q vssd1 vssd1 vccd1 vccd1 hold177/X sky130_fd_sc_hd__dlygate4sd3_1
Xhold188 _4748_/Q vssd1 vssd1 vccd1 vccd1 hold188/X sky130_fd_sc_hd__dlygate4sd3_1
Xhold199 _4635_/Q vssd1 vssd1 vccd1 vccd1 hold199/X sky130_fd_sc_hd__dlygate4sd3_1
XFILLER_85_110 vssd1 vssd1 vccd1 vccd1 sky130_fd_sc_hd__fill_2
X_4378_ _4373_/X _4377_/X hold166/X _4378_/B2 vssd1 vssd1 vccd1 vccd1 _4787_/D sky130_fd_sc_hd__o2bb2a_1
XANTENNA_input6_A s_axis_tdata[12] vssd1 vssd1 vccd1 vccd1 sky130_fd_sc_hd__diode_2
X_3329_ _3333_/B _3333_/D vssd1 vssd1 vccd1 vccd1 _3535_/D sky130_fd_sc_hd__or2_1
XANTENNA_fanout289_X _4037_/B vssd1 vssd1 vccd1 vccd1 sky130_fd_sc_hd__diode_2
XFILLER_73_305 vccd1 vssd1 vccd1 vssd1 sky130_ef_sc_hd__decap_12
XANTENNA__4227__C _4227_/C vssd1 vssd1 vccd1 vccd1 sky130_fd_sc_hd__diode_2
XFILLER_41_235 vccd1 vssd1 vccd1 vssd1 sky130_ef_sc_hd__decap_12
XFILLER_41_279 vssd1 vssd1 vccd1 vccd1 sky130_fd_sc_hd__fill_1
XFILLER_64_305 vssd1 vssd1 vccd1 vccd1 sky130_fd_sc_hd__decap_3
XFILLER_17_221 vssd1 vssd1 vccd1 vccd1 sky130_fd_sc_hd__decap_3
XTAP_TAPCELL_ROW_75_867 vssd1 vccd1 sky130_fd_sc_hd__tapvpwrvgnd_1
X_2700_ _4697_/Q _4684_/Q vssd1 vssd1 vccd1 vccd1 _2753_/C sky130_fd_sc_hd__nand2_1
XTAP_TAPCELL_ROW_30_458 vssd1 vccd1 sky130_fd_sc_hd__tapvpwrvgnd_1
X_3680_ _3679_/X _4600_/Q _3741_/S vssd1 vssd1 vccd1 vccd1 _4600_/D sky130_fd_sc_hd__mux2_1
X_2631_ _4664_/Q _4755_/Q vssd1 vssd1 vccd1 vccd1 _2632_/C sky130_fd_sc_hd__xor2_1
X_2562_ _2522_/A _2522_/B _2522_/D _2560_/Y _2519_/X vssd1 vssd1 vccd1 vccd1 _2563_/B
+ sky130_fd_sc_hd__o311ai_1
XFILLER_57_3 vssd1 vssd1 vccd1 vccd1 sky130_fd_sc_hd__fill_1
X_4301_ _4305_/A0 _4305_/A1 _4371_/A vssd1 vssd1 vccd1 vccd1 _4301_/X sky130_fd_sc_hd__mux2_1
XFILLER_87_419 vssd1 vssd1 vccd1 vccd1 sky130_fd_sc_hd__fill_1
X_4232_ _4364_/A _4240_/A2 _4240_/B1 vssd1 vssd1 vccd1 vccd1 _4232_/Y sky130_fd_sc_hd__o21ai_1
X_2493_ _4690_/Q _4677_/Q vssd1 vssd1 vccd1 vccd1 _2528_/A sky130_fd_sc_hd__nand2_1
Xclkbuf_leaf_4_clk clkload0/A vssd1 vssd1 vccd1 vccd1 clkload7/A sky130_fd_sc_hd__clkbuf_8
X_4163_ _4171_/A0 _4167_/A1 _4302_/D vssd1 vssd1 vccd1 vccd1 _4163_/X sky130_fd_sc_hd__mux2_1
X_3114_ _3114_/A _3114_/B vssd1 vssd1 vccd1 vccd1 _3114_/Y sky130_fd_sc_hd__nor2_1
XANTENNA__4328__B _4328_/B vssd1 vssd1 vccd1 vccd1 sky130_fd_sc_hd__diode_2
X_4094_ _4093_/Y _4092_/X _4091_/X hold93/X _4208_/B1 vssd1 vssd1 vccd1 vccd1 _4715_/D
+ sky130_fd_sc_hd__o32a_1
X_3045_ _4768_/Q _4783_/Q vssd1 vssd1 vccd1 vccd1 _3046_/B sky130_fd_sc_hd__xor2_1
XANTENNA__3981__A_N _3976_/D vssd1 vssd1 vccd1 vccd1 sky130_fd_sc_hd__diode_2
XANTENNA_fanout249_A _4328_/C vssd1 vssd1 vccd1 vccd1 sky130_fd_sc_hd__diode_2
XFILLER_63_393 vccd1 vssd1 vccd1 vssd1 sky130_ef_sc_hd__decap_12
XANTENNA_fanout151_A _4338_/A2 vssd1 vssd1 vccd1 vccd1 sky130_fd_sc_hd__diode_2
X_3947_ _4071_/S _3971_/A1 _4005_/D _3899_/Y vssd1 vssd1 vccd1 vccd1 _3947_/X sky130_fd_sc_hd__o2bb2a_1
XFILLER_23_279 vssd1 vssd1 vccd1 vccd1 sky130_fd_sc_hd__fill_1
XANTENNA_fanout416_A fanout424/X vssd1 vssd1 vccd1 vccd1 sky130_fd_sc_hd__diode_2
X_3878_ _3977_/B _3977_/C _3976_/D vssd1 vssd1 vccd1 vccd1 _3878_/X sky130_fd_sc_hd__and3_1
XANTENNA__3963__A2 _3873_/Y vssd1 vssd1 vccd1 vccd1 sky130_fd_sc_hd__diode_2
X_2829_ _2766_/X _2767_/Y _2777_/Y _2828_/A _2775_/Y vssd1 vssd1 vccd1 vccd1 _2830_/B
+ sky130_fd_sc_hd__a311o_1
XANTENNA__2311__B _2323_/B vssd1 vssd1 vccd1 vccd1 sky130_fd_sc_hd__diode_2
Xfanout410 fanout414/X vssd1 vssd1 vccd1 vccd1 fanout410/X sky130_fd_sc_hd__clkbuf_4
Xfanout421 fanout422/X vssd1 vssd1 vccd1 vccd1 _2229_/B sky130_fd_sc_hd__buf_2
Xfanout432 fanout434/X vssd1 vssd1 vccd1 vccd1 fanout432/X sky130_fd_sc_hd__buf_2
XFILLER_86_452 vssd1 vssd1 vccd1 vccd1 sky130_fd_sc_hd__decap_4
XFILLER_48_79 vssd1 vssd1 vccd1 vccd1 sky130_fd_sc_hd__fill_1
XFILLER_58_165 vssd1 vssd1 vccd1 vccd1 sky130_fd_sc_hd__decap_8
XFILLER_73_113 vssd1 vssd1 vccd1 vccd1 sky130_fd_sc_hd__fill_1
XTAP_TAPCELL_ROW_72_837 vssd1 vccd1 sky130_fd_sc_hd__tapvpwrvgnd_1
XTAP_TAPCELL_ROW_1_194 vssd1 vccd1 sky130_fd_sc_hd__tapvpwrvgnd_1
XFILLER_80_33 vssd1 vssd1 vccd1 vccd1 sky130_fd_sc_hd__decap_6
Xfanout83 _3333_/Y vssd1 vssd1 vccd1 vccd1 _3460_/A1 sky130_fd_sc_hd__buf_2
Xfanout94 _4411_/S vssd1 vssd1 vccd1 vccd1 _4410_/S sky130_fd_sc_hd__clkbuf_2
XFILLER_6_434 vssd1 vssd1 vccd1 vccd1 sky130_fd_sc_hd__fill_1
XFILLER_6_489 vccd1 vssd1 vccd1 vssd1 sky130_ef_sc_hd__decap_12
XFILLER_43_9 vssd1 vssd1 vccd1 vccd1 sky130_fd_sc_hd__decap_6
XFILLER_69_419 vccd1 vssd1 vccd1 vssd1 sky130_ef_sc_hd__decap_12
XTAP_TAPCELL_ROW_9_272 vssd1 vccd1 sky130_fd_sc_hd__tapvpwrvgnd_1
XFILLER_49_143 vssd1 vssd1 vccd1 vccd1 sky130_fd_sc_hd__fill_1
XANTENNA__2693__A2 _3870_/B1 vssd1 vssd1 vccd1 vccd1 sky130_fd_sc_hd__diode_2
XTAP_TAPCELL_ROW_35_506 vssd1 vccd1 sky130_fd_sc_hd__tapvpwrvgnd_1
XANTENNA_clkbuf_leaf_0_clk_A clkload0/A vssd1 vssd1 vccd1 vccd1 sky130_fd_sc_hd__diode_2
X_3801_ _2435_/Y _2439_/Y _2440_/Y vssd1 vssd1 vccd1 vccd1 _3801_/Y sky130_fd_sc_hd__a21oi_1
X_4781_ _4782_/CLK _4781_/D fanout402/X vssd1 vssd1 vccd1 vccd1 _4781_/Q sky130_fd_sc_hd__dfrtp_1
XTAP_TAPCELL_ROW_43_572 vssd1 vccd1 sky130_fd_sc_hd__tapvpwrvgnd_1
X_3732_ _4530_/Q _4639_/Q _3730_/X _3731_/Y vssd1 vssd1 vccd1 vccd1 _3732_/X sky130_fd_sc_hd__a211o_1
Xclkload20 _4748_/CLK vssd1 vssd1 vccd1 vccd1 clkload20/Y sky130_fd_sc_hd__clkinv_2
X_3663_ _4523_/Q _4632_/Q vssd1 vssd1 vccd1 vccd1 _3690_/A sky130_fd_sc_hd__xnor2_1
Xclkload42 _4612_/CLK vssd1 vssd1 vccd1 vccd1 clkload42/Y sky130_fd_sc_hd__inv_8
Xclkload31 _4553_/CLK vssd1 vssd1 vccd1 vccd1 clkload31/Y sky130_fd_sc_hd__clkinv_2
X_2614_ _2615_/B _2615_/A vssd1 vssd1 vccd1 vccd1 _2614_/Y sky130_fd_sc_hd__nor2_1
XANTENNA__4103__S _4803_/Q vssd1 vssd1 vccd1 vccd1 sky130_fd_sc_hd__diode_2
X_3594_ _4515_/Q _4624_/Q vssd1 vssd1 vccd1 vccd1 _3594_/X sky130_fd_sc_hd__xor2_1
X_2545_ _4692_/Q _4679_/Q vssd1 vssd1 vccd1 vccd1 _2545_/Y sky130_fd_sc_hd__nor2_1
X_2476_ _2474_/A _2475_/X hold152/X _3806_/A2 vssd1 vssd1 vccd1 vccd1 _4514_/D sky130_fd_sc_hd__o2bb2a_1
XFILLER_87_249 vssd1 vssd1 vccd1 vccd1 sky130_fd_sc_hd__decap_3
X_4215_ _4243_/A2 _4239_/B _4215_/C _4223_/D vssd1 vssd1 vccd1 vccd1 _4215_/X sky130_fd_sc_hd__and4b_1
XFILLER_68_474 vssd1 vssd1 vccd1 vccd1 sky130_fd_sc_hd__fill_2
X_4146_ _4143_/X _4144_/X _4145_/Y _4208_/B1 hold118/X vssd1 vssd1 vccd1 vccd1 _4728_/D
+ sky130_fd_sc_hd__o32a_1
XANTENNA_fanout199_A _2424_/S vssd1 vssd1 vccd1 vccd1 sky130_fd_sc_hd__diode_2
XFILLER_83_411 vssd1 vssd1 vccd1 vccd1 sky130_fd_sc_hd__decap_8
XFILLER_28_327 vssd1 vssd1 vccd1 vccd1 sky130_fd_sc_hd__fill_1
XFILLER_83_466 vccd1 vssd1 vccd1 vssd1 sky130_ef_sc_hd__decap_12
X_4077_ _4273_/S _4105_/A2 _4193_/B2 vssd1 vssd1 vccd1 vccd1 _4077_/Y sky130_fd_sc_hd__o21ai_1
XFILLER_70_116 vssd1 vssd1 vccd1 vccd1 sky130_fd_sc_hd__fill_1
X_3028_ _3028_/A _3028_/B _3028_/C vssd1 vssd1 vccd1 vccd1 _3029_/B sky130_fd_sc_hd__nand3_1
XFILLER_36_371 vccd1 vssd1 vccd1 vssd1 sky130_ef_sc_hd__decap_12
XFILLER_70_149 vssd1 vssd1 vccd1 vccd1 sky130_fd_sc_hd__decap_3
XFILLER_51_330 vssd1 vssd1 vccd1 vccd1 sky130_fd_sc_hd__fill_2
XFILLER_11_238 vssd1 vssd1 vccd1 vccd1 sky130_fd_sc_hd__fill_1
Xclkload3 clkload3/A vssd1 vssd1 vccd1 vccd1 clkload3/X sky130_fd_sc_hd__clkbuf_4
XANTENNA_fanout321_X _4273_/S vssd1 vssd1 vccd1 vccd1 sky130_fd_sc_hd__diode_2
XFILLER_78_249 vssd1 vssd1 vccd1 vccd1 sky130_fd_sc_hd__decap_3
XTAP_TAPCELL_ROW_6_242 vssd1 vccd1 sky130_fd_sc_hd__tapvpwrvgnd_1
XANTENNA__4113__A2 _4171_/A1 vssd1 vssd1 vccd1 vccd1 sky130_fd_sc_hd__diode_2
Xfanout240 _2250_/S vssd1 vssd1 vccd1 vccd1 _2271_/S sky130_fd_sc_hd__buf_2
Xfanout262 _4306_/C vssd1 vssd1 vccd1 vccd1 _4243_/A2 sky130_fd_sc_hd__clkbuf_2
Xfanout273 _4175_/B vssd1 vssd1 vccd1 vccd1 _4172_/B sky130_fd_sc_hd__clkbuf_2
Xfanout251 _2205_/Y vssd1 vssd1 vccd1 vccd1 _2295_/C sky130_fd_sc_hd__buf_2
Xfanout295 _4374_/S vssd1 vssd1 vccd1 vccd1 _4238_/S sky130_fd_sc_hd__buf_2
Xfanout284 _4009_/A_N vssd1 vssd1 vccd1 vccd1 _4064_/C sky130_fd_sc_hd__clkbuf_2
XTAP_TAPCELL_ROW_85_951 vssd1 vccd1 sky130_fd_sc_hd__tapvpwrvgnd_1
XFILLER_74_444 vssd1 vssd1 vccd1 vccd1 sky130_fd_sc_hd__decap_8
XFILLER_61_116 vssd1 vssd1 vccd1 vccd1 sky130_fd_sc_hd__fill_1
XFILLER_27_393 vccd1 vssd1 vccd1 vssd1 sky130_ef_sc_hd__decap_12
XFILLER_42_352 vssd1 vssd1 vccd1 vccd1 sky130_fd_sc_hd__decap_4
XFILLER_42_363 vssd1 vssd1 vccd1 vccd1 sky130_fd_sc_hd__fill_1
XANTENNA_clkbuf_2_3__f_clk_X clkbuf_2_3__f_clk/X vssd1 vssd1 vccd1 vccd1 sky130_fd_sc_hd__diode_2
XTAP_TAPCELL_ROW_40_553 vssd1 vccd1 sky130_fd_sc_hd__tapvpwrvgnd_1
XTAP_TAPCELL_ROW_12_299 vssd1 vccd1 sky130_fd_sc_hd__tapvpwrvgnd_1
XFILLER_6_253 vssd1 vssd1 vccd1 vccd1 sky130_fd_sc_hd__decap_4
XFILLER_6_286 vccd1 vssd1 vccd1 vssd1 sky130_ef_sc_hd__decap_12
XFILLER_69_216 vssd1 vssd1 vccd1 vccd1 sky130_fd_sc_hd__decap_8
X_2330_ _2341_/A0 _2341_/A1 _4033_/D vssd1 vssd1 vccd1 vccd1 _2330_/X sky130_fd_sc_hd__mux2_1
X_2261_ hold42/X _4569_/Q _2270_/S vssd1 vssd1 vccd1 vccd1 _4440_/D sky130_fd_sc_hd__mux2_1
X_4000_ _4020_/A0 _4020_/A1 _4005_/D vssd1 vssd1 vccd1 vccd1 _4000_/X sky130_fd_sc_hd__mux2_1
XFILLER_65_400 vssd1 vssd1 vccd1 vccd1 sky130_fd_sc_hd__fill_1
XFILLER_1_30 vccd1 vssd1 vccd1 vssd1 sky130_ef_sc_hd__decap_12
XTAP_TAPCELL_ROW_48_620 vssd1 vccd1 sky130_fd_sc_hd__tapvpwrvgnd_1
XFILLER_77_293 vccd1 vssd1 vccd1 vssd1 sky130_ef_sc_hd__decap_12
XFILLER_37_135 vccd1 vssd1 vccd1 vssd1 sky130_ef_sc_hd__decap_12
XFILLER_52_105 vssd1 vssd1 vccd1 vccd1 sky130_fd_sc_hd__fill_1
XFILLER_21_503 vssd1 vssd1 vccd1 vccd1 sky130_fd_sc_hd__fill_1
X_4764_ _4782_/CLK _4764_/D fanout402/X vssd1 vssd1 vccd1 vccd1 _4764_/Q sky130_fd_sc_hd__dfrtp_2
XFILLER_60_193 vssd1 vssd1 vccd1 vccd1 sky130_fd_sc_hd__decap_3
XANTENNA__4040__B2 _4036_/S vssd1 vssd1 vccd1 vccd1 sky130_fd_sc_hd__diode_2
X_3715_ _4530_/Q _4639_/Q vssd1 vssd1 vccd1 vccd1 _3716_/B sky130_fd_sc_hd__and2_1
X_4695_ clkload7/A _4695_/D fanout381/X vssd1 vssd1 vccd1 vccd1 hold97/A sky130_fd_sc_hd__dfrtp_1
XANTENNA_fanout114_A _2797_/A2 vssd1 vssd1 vccd1 vccd1 sky130_fd_sc_hd__diode_2
XANTENNA__4060__C _4064_/C vssd1 vssd1 vccd1 vccd1 sky130_fd_sc_hd__diode_2
X_3646_ _4521_/Q _4630_/Q vssd1 vssd1 vccd1 vccd1 _3647_/B sky130_fd_sc_hd__nor2_1
X_3577_ _4513_/Q _4622_/Q vssd1 vssd1 vccd1 vccd1 _3579_/A sky130_fd_sc_hd__nand2_1
X_2528_ _2528_/A _2528_/B _2528_/C vssd1 vssd1 vccd1 vccd1 _2529_/B sky130_fd_sc_hd__and3_1
Xhold15 hold15/A vssd1 vssd1 vccd1 vccd1 hold15/X sky130_fd_sc_hd__dlygate4sd3_1
X_2459_ _4660_/Q _2459_/B vssd1 vssd1 vccd1 vccd1 _2459_/Y sky130_fd_sc_hd__xnor2_1
Xhold26 hold26/A vssd1 vssd1 vccd1 vccd1 hold26/X sky130_fd_sc_hd__dlygate4sd3_1
Xhold37 hold37/A vssd1 vssd1 vccd1 vccd1 hold37/X sky130_fd_sc_hd__dlygate4sd3_1
Xhold59 hold59/A vssd1 vssd1 vccd1 vccd1 hold59/X sky130_fd_sc_hd__dlygate4sd3_1
XFILLER_75_219 vssd1 vssd1 vccd1 vccd1 sky130_fd_sc_hd__decap_4
Xhold48 hold48/A vssd1 vssd1 vccd1 vccd1 hold48/X sky130_fd_sc_hd__dlygate4sd3_1
XTAP_TAPCELL_ROW_3_212 vssd1 vccd1 sky130_fd_sc_hd__tapvpwrvgnd_1
XANTENNA_fanout271_X _4239_/D vssd1 vssd1 vccd1 vccd1 sky130_fd_sc_hd__diode_2
XFILLER_68_293 vccd1 vssd1 vccd1 vssd1 sky130_ef_sc_hd__decap_12
XFILLER_28_135 vssd1 vssd1 vccd1 vccd1 sky130_fd_sc_hd__fill_1
X_4129_ _4323_/S _4173_/A2 _4130_/B1 vssd1 vssd1 vccd1 vccd1 _4129_/Y sky130_fd_sc_hd__o21ai_1
XFILLER_28_168 vssd1 vssd1 vccd1 vccd1 sky130_fd_sc_hd__fill_1
XANTENNA__4008__S _4075_/S vssd1 vssd1 vccd1 vccd1 sky130_fd_sc_hd__diode_2
XFILLER_43_127 vssd1 vssd1 vccd1 vccd1 sky130_fd_sc_hd__fill_2
XANTENNA__4235__C _4368_/A vssd1 vssd1 vccd1 vccd1 sky130_fd_sc_hd__diode_2
XTAP_TAPCELL_ROW_54_678 vssd1 vccd1 sky130_fd_sc_hd__tapvpwrvgnd_1
XANTENNA__3909__A2 _4081_/A2 vssd1 vssd1 vccd1 vccd1 sky130_fd_sc_hd__diode_2
XFILLER_86_65 vccd1 vssd1 vccd1 vssd1 sky130_ef_sc_hd__decap_12
XFILLER_66_219 vssd1 vssd1 vccd1 vccd1 sky130_fd_sc_hd__decap_8
XFILLER_19_113 vccd1 vssd1 vccd1 vssd1 sky130_ef_sc_hd__decap_12
XFILLER_47_499 vssd1 vssd1 vccd1 vccd1 sky130_fd_sc_hd__fill_1
XFILLER_34_116 vssd1 vssd1 vccd1 vccd1 sky130_fd_sc_hd__decap_8
XFILLER_42_160 vccd1 vssd1 vccd1 vssd1 sky130_ef_sc_hd__decap_12
X_3500_ _3536_/A2 _3498_/Y _3499_/X _3525_/B1 vssd1 vssd1 vccd1 vccd1 _3500_/X sky130_fd_sc_hd__a31o_1
XPHY_EDGE_ROW_2_Left_90 vssd1 vssd1 vccd1 vccd1 sky130_fd_sc_hd__decap_3
X_4480_ _4553_/CLK _4480_/D fanout420/X vssd1 vssd1 vccd1 vccd1 hold7/A sky130_fd_sc_hd__dfrtp_1
X_3431_ _4558_/Q _4599_/Q _3208_/Y _3421_/Y vssd1 vssd1 vccd1 vccd1 _3432_/B sky130_fd_sc_hd__a2bb2oi_1
XANTENNA__4325__A2 _4328_/C vssd1 vssd1 vccd1 vccd1 sky130_fd_sc_hd__diode_2
X_3362_ _3383_/A1 _3361_/X _3383_/B1 vssd1 vssd1 vccd1 vccd1 _3362_/X sky130_fd_sc_hd__a21o_1
X_2313_ _4460_/Q _3995_/B2 _2312_/X _2310_/X vssd1 vssd1 vccd1 vccd1 _4460_/D sky130_fd_sc_hd__o22a_1
XFILLER_85_517 vssd1 vssd1 vccd1 vccd1 sky130_fd_sc_hd__fill_2
X_3293_ _3294_/B vssd1 vssd1 vccd1 vccd1 _3293_/Y sky130_fd_sc_hd__inv_2
XANTENNA__4089__A1 _4223_/C vssd1 vssd1 vccd1 vccd1 sky130_fd_sc_hd__diode_2
X_2244_ hold80/X _4552_/Q _2249_/S vssd1 vssd1 vccd1 vccd1 _4423_/D sky130_fd_sc_hd__mux2_1
XFILLER_65_241 vccd1 vssd1 vccd1 vssd1 sky130_ef_sc_hd__decap_12
XFILLER_38_433 vssd1 vssd1 vccd1 vccd1 sky130_fd_sc_hd__decap_8
XFILLER_53_447 vssd1 vssd1 vccd1 vccd1 sky130_fd_sc_hd__fill_1
X_4816_ _4817_/CLK _4816_/D fanout397/X vssd1 vssd1 vccd1 vccd1 _4816_/Q sky130_fd_sc_hd__dfrtp_1
XANTENNA__4352__A _4352_/A vssd1 vssd1 vccd1 vccd1 sky130_fd_sc_hd__diode_2
XTAP_TAPCELL_ROW_51_648 vssd1 vccd1 sky130_fd_sc_hd__tapvpwrvgnd_1
XANTENNA_fanout329_A _2304_/A1 vssd1 vssd1 vccd1 vccd1 sky130_fd_sc_hd__diode_2
X_4747_ _4748_/CLK _4747_/D fanout390/X vssd1 vssd1 vccd1 vccd1 _4747_/Q sky130_fd_sc_hd__dfrtp_1
XANTENNA_fanout117_X _2797_/A2 vssd1 vssd1 vccd1 vccd1 sky130_fd_sc_hd__diode_2
X_4678_ _4808_/CLK _4678_/D fanout378/X vssd1 vssd1 vccd1 vccd1 _4678_/Q sky130_fd_sc_hd__dfrtp_1
X_3629_ _3608_/X _3593_/Y _3628_/A vssd1 vssd1 vccd1 vccd1 _3657_/A sky130_fd_sc_hd__o21bai_1
Xoutput38 hold82/A vssd1 vssd1 vccd1 vccd1 m_axis_tdata[10] sky130_fd_sc_hd__buf_2
Xoutput49 hold34/A vssd1 vssd1 vccd1 vccd1 m_axis_tdata[20] sky130_fd_sc_hd__buf_2
XFILLER_0_215 vssd1 vssd1 vccd1 vccd1 sky130_fd_sc_hd__decap_8
XFILLER_0_237 vccd1 vssd1 vccd1 vssd1 sky130_ef_sc_hd__decap_12
XFILLER_76_517 vssd1 vssd1 vccd1 vccd1 sky130_fd_sc_hd__fill_2
XTAP_TAPCELL_ROW_67_792 vssd1 vccd1 sky130_fd_sc_hd__tapvpwrvgnd_1
XFILLER_16_138 vssd1 vssd1 vccd1 vccd1 sky130_fd_sc_hd__fill_2
XFILLER_71_288 vssd1 vssd1 vccd1 vccd1 sky130_fd_sc_hd__fill_2
XTAP_TAPCELL_ROW_14_317 vssd1 vccd1 sky130_fd_sc_hd__tapvpwrvgnd_1
XANTENNA_clkbuf_leaf_40_clk_A clkload2/A vssd1 vssd1 vccd1 vccd1 sky130_fd_sc_hd__diode_2
XFILLER_24_182 vssd1 vssd1 vccd1 vccd1 sky130_fd_sc_hd__decap_6
XANTENNA__4004__A1 _4020_/A1 vssd1 vssd1 vccd1 vccd1 sky130_fd_sc_hd__diode_2
XTAP_TAPCELL_ROW_22_383 vssd1 vccd1 sky130_fd_sc_hd__tapvpwrvgnd_1
XFILLER_79_377 vccd1 vssd1 vccd1 vssd1 sky130_ef_sc_hd__decap_12
XFILLER_39_219 vssd1 vssd1 vccd1 vccd1 sky130_fd_sc_hd__decap_4
XFILLER_35_447 vssd1 vssd1 vccd1 vccd1 sky130_fd_sc_hd__fill_1
X_3980_ _4020_/A0 _4020_/A1 _3985_/D vssd1 vssd1 vccd1 vccd1 _3980_/X sky130_fd_sc_hd__mux2_1
XFILLER_35_458 vssd1 vssd1 vccd1 vccd1 sky130_fd_sc_hd__decap_3
X_2931_ _2928_/A _2928_/B _2927_/A vssd1 vssd1 vccd1 vccd1 _2944_/A sky130_fd_sc_hd__o21ai_1
Xclkbuf_0_clk clk vssd1 vssd1 vccd1 vccd1 clkbuf_0_clk/X sky130_fd_sc_hd__clkbuf_16
XFILLER_87_3 vccd1 vssd1 vccd1 vssd1 sky130_ef_sc_hd__decap_12
XFILLER_30_141 vssd1 vssd1 vccd1 vccd1 sky130_fd_sc_hd__fill_1
X_4601_ _4635_/CLK _4601_/D fanout426/X vssd1 vssd1 vccd1 vccd1 _4601_/Q sky130_fd_sc_hd__dfrtp_1
X_2862_ _2812_/A _2814_/A _2861_/B _2861_/C vssd1 vssd1 vccd1 vccd1 _2862_/Y sky130_fd_sc_hd__o211ai_1
X_2793_ _2793_/A _2793_/B vssd1 vssd1 vccd1 vccd1 _2794_/B sky130_fd_sc_hd__nand2_1
X_4532_ _4644_/CLK _4532_/D fanout428/X vssd1 vssd1 vccd1 vccd1 _4532_/Q sky130_fd_sc_hd__dfrtp_1
XFILLER_7_51 vssd1 vssd1 vccd1 vccd1 sky130_fd_sc_hd__decap_4
X_4463_ clkload8/A _4463_/D fanout381/X vssd1 vssd1 vccd1 vccd1 _4463_/Q sky130_fd_sc_hd__dfrtp_1
X_3414_ _4596_/Q _3424_/A2 _3541_/B1 _3613_/C vssd1 vssd1 vccd1 vccd1 _3414_/X sky130_fd_sc_hd__o211a_1
X_4394_ _4238_/S input9/X _4406_/S vssd1 vssd1 vccd1 vccd1 _4803_/D sky130_fd_sc_hd__mux2_1
XPHY_EDGE_ROW_15_Right_15 vssd1 vssd1 vccd1 vccd1 sky130_fd_sc_hd__decap_3
X_3345_ _3343_/X _3345_/B vssd1 vssd1 vccd1 vccd1 _3345_/Y sky130_fd_sc_hd__nand2b_1
X_3276_ _3282_/A _4589_/Q _4588_/Q _4547_/Q vssd1 vssd1 vccd1 vccd1 _3276_/X sky130_fd_sc_hd__a22o_1
X_2227_ _4539_/Q _4540_/Q vssd1 vssd1 vccd1 vccd1 _2227_/X sky130_fd_sc_hd__and2b_1
XFILLER_85_369 vssd1 vssd1 vccd1 vccd1 sky130_fd_sc_hd__decap_3
XFILLER_26_27 vssd1 vssd1 vccd1 vccd1 sky130_fd_sc_hd__fill_1
XFILLER_26_425 vccd1 vssd1 vccd1 vssd1 sky130_ef_sc_hd__decap_12
XTAP_TAPCELL_ROW_64_762 vssd1 vccd1 sky130_fd_sc_hd__tapvpwrvgnd_1
XPHY_EDGE_ROW_24_Right_24 vssd1 vssd1 vccd1 vccd1 sky130_fd_sc_hd__decap_3
XFILLER_41_428 vssd1 vssd1 vccd1 vccd1 sky130_fd_sc_hd__decap_3
XFILLER_42_15 vssd1 vssd1 vccd1 vccd1 sky130_fd_sc_hd__fill_1
XPHY_EDGE_ROW_33_Right_33 vssd1 vssd1 vccd1 vccd1 sky130_fd_sc_hd__decap_3
XANTENNA_fanout94_A _4411_/S vssd1 vssd1 vccd1 vccd1 sky130_fd_sc_hd__diode_2
XFILLER_76_336 vssd1 vssd1 vccd1 vccd1 sky130_fd_sc_hd__fill_2
XPHY_EDGE_ROW_42_Right_42 vssd1 vssd1 vccd1 vccd1 sky130_fd_sc_hd__decap_3
XFILLER_83_55 vssd1 vssd1 vccd1 vccd1 sky130_fd_sc_hd__fill_1
XTAP_TAPCELL_ROW_27_431 vssd1 vccd1 sky130_fd_sc_hd__tapvpwrvgnd_1
XFILLER_32_417 vssd1 vssd1 vccd1 vccd1 sky130_fd_sc_hd__decap_3
XFILLER_44_288 vccd1 vssd1 vccd1 vssd1 sky130_ef_sc_hd__decap_12
XANTENNA__3984__A0 _4020_/A0 vssd1 vssd1 vccd1 vccd1 sky130_fd_sc_hd__diode_2
XPHY_EDGE_ROW_51_Right_51 vssd1 vssd1 vccd1 vccd1 sky130_fd_sc_hd__decap_3
XFILLER_59_7 vssd1 vssd1 vccd1 vccd1 sky130_fd_sc_hd__fill_1
XFILLER_79_130 vssd1 vssd1 vccd1 vccd1 sky130_fd_sc_hd__decap_8
X_3130_ _3130_/A _3130_/B vssd1 vssd1 vccd1 vccd1 _3132_/C sky130_fd_sc_hd__nand2_1
XFILLER_67_325 vssd1 vssd1 vccd1 vccd1 sky130_fd_sc_hd__decap_6
XTAP_TAPCELL_ROW_78_887 vssd1 vccd1 sky130_fd_sc_hd__tapvpwrvgnd_1
X_3061_ _3150_/A _3061_/B vssd1 vssd1 vccd1 vccd1 _3063_/C sky130_fd_sc_hd__nand2_1
XPHY_EDGE_ROW_60_Right_60 vssd1 vssd1 vccd1 vccd1 sky130_fd_sc_hd__decap_3
XANTENNA__4216__A1 _4215_/C vssd1 vssd1 vccd1 vccd1 sky130_fd_sc_hd__diode_2
XFILLER_23_406 vssd1 vssd1 vccd1 vccd1 sky130_fd_sc_hd__fill_2
X_3963_ _4029_/D _3873_/Y _3962_/X _4038_/B1 vssd1 vssd1 vccd1 vccd1 _3963_/X sky130_fd_sc_hd__o211a_1
XANTENNA__3424__C1 _3923_/A vssd1 vssd1 vccd1 vccd1 sky130_fd_sc_hd__diode_2
XFILLER_50_225 vssd1 vssd1 vccd1 vccd1 sky130_fd_sc_hd__fill_1
XFILLER_31_461 vssd1 vssd1 vccd1 vccd1 sky130_fd_sc_hd__decap_6
X_3894_ _4281_/A0 _4656_/Q _4314_/S vssd1 vssd1 vccd1 vccd1 _4656_/D sky130_fd_sc_hd__mux2_1
XFILLER_50_269 vssd1 vssd1 vccd1 vccd1 sky130_fd_sc_hd__fill_1
X_2914_ _2914_/A _2914_/B vssd1 vssd1 vccd1 vccd1 _2916_/B sky130_fd_sc_hd__xor2_1
XTAP_TAPCELL_ROW_33_489 vssd1 vccd1 sky130_fd_sc_hd__tapvpwrvgnd_1
X_2845_ _2845_/A _2845_/B _2845_/C vssd1 vssd1 vccd1 vccd1 _2847_/A sky130_fd_sc_hd__or3_1
Xhold101 _4661_/Q vssd1 vssd1 vccd1 vccd1 hold101/X sky130_fd_sc_hd__dlygate4sd3_1
X_4515_ _4624_/CLK _4515_/D fanout407/X vssd1 vssd1 vccd1 vccd1 _4515_/Q sky130_fd_sc_hd__dfrtp_1
X_2776_ _2775_/A _2775_/B _2775_/C _2775_/D vssd1 vssd1 vccd1 vccd1 _2776_/X sky130_fd_sc_hd__o22a_1
XANTENNA__4116__A_N _4199_/D vssd1 vssd1 vccd1 vccd1 sky130_fd_sc_hd__diode_2
Xhold112 _4463_/Q vssd1 vssd1 vccd1 vccd1 hold112/X sky130_fd_sc_hd__dlygate4sd3_1
Xhold134 _4775_/Q vssd1 vssd1 vccd1 vccd1 hold134/X sky130_fd_sc_hd__dlygate4sd3_1
Xhold123 _4716_/Q vssd1 vssd1 vccd1 vccd1 hold123/X sky130_fd_sc_hd__dlygate4sd3_1
Xhold145 _4818_/Q vssd1 vssd1 vccd1 vccd1 hold145/X sky130_fd_sc_hd__dlygate4sd3_1
X_4446_ _4576_/CLK _4446_/D fanout437/X vssd1 vssd1 vccd1 vccd1 hold65/A sky130_fd_sc_hd__dfrtp_1
Xhold167 _4458_/Q vssd1 vssd1 vccd1 vccd1 hold167/X sky130_fd_sc_hd__dlygate4sd3_1
Xhold156 _4630_/Q vssd1 vssd1 vccd1 vccd1 hold156/X sky130_fd_sc_hd__dlygate4sd3_1
X_4377_ _4374_/S _2224_/Y _4371_/B _4377_/B1 _4377_/C1 vssd1 vssd1 vccd1 vccd1 _4377_/X
+ sky130_fd_sc_hd__o311a_1
Xhold178 _4532_/Q vssd1 vssd1 vccd1 vccd1 hold178/X sky130_fd_sc_hd__dlygate4sd3_1
Xhold189 _4531_/Q vssd1 vssd1 vccd1 vccd1 hold189/X sky130_fd_sc_hd__dlygate4sd3_1
XANTENNA_fanout396_A fanout398/X vssd1 vssd1 vccd1 vccd1 sky130_fd_sc_hd__diode_2
XTAP_TAPCELL_ROW_69_810 vssd1 vccd1 sky130_fd_sc_hd__tapvpwrvgnd_1
XANTENNA__3680__S _3741_/S vssd1 vssd1 vccd1 vccd1 sky130_fd_sc_hd__diode_2
X_3328_ _3333_/D _3333_/B vssd1 vssd1 vccd1 vccd1 _3535_/C sky130_fd_sc_hd__nand2_1
XFILLER_73_317 vccd1 vssd1 vccd1 vssd1 sky130_ef_sc_hd__decap_12
X_3259_ _4544_/Q _4585_/Q vssd1 vssd1 vccd1 vccd1 _3266_/B sky130_fd_sc_hd__xor2_2
XFILLER_81_361 vccd1 vssd1 vccd1 vssd1 sky130_ef_sc_hd__decap_12
XTAP_TAPCELL_ROW_24_401 vssd1 vccd1 sky130_fd_sc_hd__tapvpwrvgnd_1
XFILLER_41_225 vssd1 vssd1 vccd1 vccd1 sky130_fd_sc_hd__fill_1
XFILLER_41_247 vssd1 vssd1 vccd1 vccd1 sky130_fd_sc_hd__decap_4
XANTENNA__4391__A0 _4231_/C vssd1 vssd1 vccd1 vccd1 sky130_fd_sc_hd__diode_2
XANTENNA__4143__A0 _4171_/A0 vssd1 vssd1 vccd1 vccd1 sky130_fd_sc_hd__diode_2
XTAP_TAPCELL_ROW_75_868 vssd1 vccd1 sky130_fd_sc_hd__tapvpwrvgnd_1
XFILLER_17_233 vssd1 vssd1 vccd1 vccd1 sky130_fd_sc_hd__decap_3
XANTENNA__3976__D _3976_/D vssd1 vssd1 vccd1 vccd1 sky130_fd_sc_hd__diode_2
XFILLER_32_225 vssd1 vssd1 vccd1 vccd1 sky130_fd_sc_hd__decap_3
XFILLER_43_91 vssd1 vssd1 vccd1 vccd1 sky130_fd_sc_hd__fill_2
XTAP_TAPCELL_ROW_30_459 vssd1 vccd1 sky130_fd_sc_hd__tapvpwrvgnd_1
X_2630_ _2629_/C _2629_/A _2629_/B vssd1 vssd1 vccd1 vccd1 _2632_/B sky130_fd_sc_hd__o21ai_1
XANTENNA__4382__A0 _4123_/S vssd1 vssd1 vccd1 vccd1 sky130_fd_sc_hd__diode_2
X_2561_ _2560_/Y _2561_/B vssd1 vssd1 vccd1 vccd1 _2563_/A sky130_fd_sc_hd__nand2b_1
X_4300_ _4299_/Y _4298_/X _4297_/X _4767_/Q _4369_/B1 vssd1 vssd1 vccd1 vccd1 _4767_/D
+ sky130_fd_sc_hd__o32a_1
X_2492_ _4515_/Q _2565_/B2 _2491_/Y vssd1 vssd1 vccd1 vccd1 _4515_/D sky130_fd_sc_hd__o21a_1
X_4231_ _4243_/A2 _4814_/Q _4231_/C _4231_/D vssd1 vssd1 vccd1 vccd1 _4231_/X sky130_fd_sc_hd__and4b_1
XFILLER_4_85 vssd1 vssd1 vccd1 vccd1 sky130_fd_sc_hd__decap_4
X_4162_ _4159_/X _4160_/X _4161_/Y _4280_/B2 hold85/X vssd1 vssd1 vccd1 vccd1 _4732_/D
+ sky130_fd_sc_hd__o32a_1
X_3113_ _3104_/A _3104_/B _3112_/A _3112_/B vssd1 vssd1 vccd1 vccd1 _3114_/B sky130_fd_sc_hd__o2bb2a_1
XFILLER_67_155 vssd1 vssd1 vccd1 vccd1 sky130_fd_sc_hd__fill_1
X_4093_ _4227_/C _4105_/A2 _4205_/B2 vssd1 vssd1 vccd1 vccd1 _4093_/Y sky130_fd_sc_hd__o21ai_1
X_3044_ _4768_/Q _4783_/Q vssd1 vssd1 vccd1 vccd1 _3044_/Y sky130_fd_sc_hd__nand2_1
XANTENNA__4328__C _4328_/C vssd1 vssd1 vccd1 vccd1 sky130_fd_sc_hd__diode_2
XFILLER_70_309 vssd1 vssd1 vccd1 vccd1 sky130_fd_sc_hd__decap_4
X_3946_ _3946_/A1 _3946_/A2 _3944_/X _3945_/X vssd1 vssd1 vccd1 vccd1 _4675_/D sky130_fd_sc_hd__a31o_1
XFILLER_23_39 vssd1 vssd1 vccd1 vccd1 sky130_fd_sc_hd__fill_1
X_3877_ _4808_/Q _4033_/C vssd1 vssd1 vccd1 vccd1 _3977_/C sky130_fd_sc_hd__nand2_1
XANTENNA__4360__A _4360_/A vssd1 vssd1 vccd1 vccd1 sky130_fd_sc_hd__diode_2
XANTENNA_fanout311_A _4798_/Q vssd1 vssd1 vccd1 vccd1 sky130_fd_sc_hd__diode_2
XANTENNA_fanout409_A fanout414/X vssd1 vssd1 vccd1 vccd1 sky130_fd_sc_hd__diode_2
X_2828_ _2828_/A _2828_/B vssd1 vssd1 vccd1 vccd1 _2850_/B sky130_fd_sc_hd__nand2_1
X_2759_ _2758_/B _2758_/C _2758_/A vssd1 vssd1 vccd1 vccd1 _2760_/B sky130_fd_sc_hd__a21oi_1
X_4429_ _4668_/CLK _4429_/D _2229_/B vssd1 vssd1 vccd1 vccd1 hold64/A sky130_fd_sc_hd__dfrtp_1
Xfanout422 fanout423/X vssd1 vssd1 vccd1 vccd1 fanout422/X sky130_fd_sc_hd__clkbuf_2
Xfanout411 fanout414/X vssd1 vssd1 vccd1 vccd1 fanout411/X sky130_fd_sc_hd__buf_2
Xfanout400 fanout401/X vssd1 vssd1 vccd1 vccd1 fanout400/X sky130_fd_sc_hd__clkbuf_2
Xfanout433 fanout434/X vssd1 vssd1 vccd1 vccd1 fanout433/X sky130_fd_sc_hd__buf_2
XFILLER_73_158 vssd1 vssd1 vccd1 vccd1 sky130_fd_sc_hd__fill_1
XTAP_TAPCELL_ROW_72_838 vssd1 vccd1 sky130_fd_sc_hd__tapvpwrvgnd_1
XTAP_TAPCELL_ROW_1_195 vssd1 vccd1 sky130_fd_sc_hd__tapvpwrvgnd_1
Xfanout84 _3423_/B1 vssd1 vssd1 vccd1 vccd1 _3383_/B1 sky130_fd_sc_hd__buf_2
Xfanout95 _3923_/X vssd1 vssd1 vccd1 vccd1 _4411_/S sky130_fd_sc_hd__clkbuf_4
XFILLER_13_83 vssd1 vssd1 vccd1 vccd1 sky130_fd_sc_hd__fill_2
XFILLER_69_409 vssd1 vssd1 vccd1 vccd1 sky130_fd_sc_hd__decap_3
XTAP_TAPCELL_ROW_9_273 vssd1 vccd1 sky130_fd_sc_hd__tapvpwrvgnd_1
XFILLER_49_111 vssd1 vssd1 vccd1 vccd1 sky130_fd_sc_hd__fill_1
XFILLER_37_306 vccd1 vssd1 vccd1 vssd1 sky130_ef_sc_hd__decap_12
XFILLER_64_103 vssd1 vssd1 vccd1 vccd1 sky130_fd_sc_hd__decap_4
XTAP_TAPCELL_ROW_35_507 vssd1 vccd1 sky130_fd_sc_hd__tapvpwrvgnd_1
XFILLER_52_309 vccd1 vssd1 vccd1 vssd1 sky130_ef_sc_hd__decap_12
X_4780_ _4780_/CLK _4780_/D fanout402/X vssd1 vssd1 vccd1 vccd1 _4780_/Q sky130_fd_sc_hd__dfrtp_1
X_3800_ _4618_/Q _3795_/S _3798_/X _3799_/Y vssd1 vssd1 vccd1 vccd1 _4618_/D sky130_fd_sc_hd__a22o_1
XTAP_TAPCELL_ROW_43_573 vssd1 vccd1 sky130_fd_sc_hd__tapvpwrvgnd_1
X_3731_ _3689_/A _3727_/C _3729_/X vssd1 vssd1 vccd1 vccd1 _3731_/Y sky130_fd_sc_hd__o21ai_1
XFILLER_60_397 vssd1 vssd1 vccd1 vccd1 sky130_fd_sc_hd__fill_1
XFILLER_9_262 vccd1 vssd1 vccd1 vssd1 sky130_ef_sc_hd__decap_12
Xclkload10 _4702_/CLK vssd1 vssd1 vccd1 vccd1 clkload10/Y sky130_fd_sc_hd__clkinv_2
X_3662_ _4523_/Q _4632_/Q vssd1 vssd1 vccd1 vccd1 _3662_/Y sky130_fd_sc_hd__nand2_1
Xclkload43 _4613_/CLK vssd1 vssd1 vccd1 vccd1 clkload43/Y sky130_fd_sc_hd__clkinv_8
Xclkload21 _4751_/CLK vssd1 vssd1 vccd1 vccd1 clkload21/Y sky130_fd_sc_hd__inv_4
Xclkload32 _4549_/CLK vssd1 vssd1 vccd1 vccd1 clkload32/Y sky130_fd_sc_hd__clkinv_2
X_3593_ _3588_/Y _3587_/Y _3587_/A vssd1 vssd1 vccd1 vccd1 _3593_/Y sky130_fd_sc_hd__a21oi_1
X_2613_ _2613_/A _2613_/B vssd1 vssd1 vccd1 vccd1 _2615_/B sky130_fd_sc_hd__nand2_1
X_2544_ _4692_/Q _4679_/Q vssd1 vssd1 vccd1 vccd1 _2588_/C sky130_fd_sc_hd__nand2_2
X_2475_ _2489_/A _2472_/Y _2474_/Y _3943_/A2 _4666_/Q vssd1 vssd1 vccd1 vccd1 _2475_/X
+ sky130_fd_sc_hd__o311a_1
X_4214_ _4214_/A0 _4238_/A1 _4219_/C vssd1 vssd1 vccd1 vccd1 _4214_/X sky130_fd_sc_hd__mux2_1
X_4145_ _4273_/S _4176_/A2 _4208_/B1 vssd1 vssd1 vccd1 vccd1 _4145_/Y sky130_fd_sc_hd__o21ai_1
XFILLER_83_445 vssd1 vssd1 vccd1 vccd1 sky130_fd_sc_hd__decap_3
X_4076_ _4148_/C _4810_/Q _4104_/C _4273_/S vssd1 vssd1 vccd1 vccd1 _4076_/X sky130_fd_sc_hd__and4b_1
XFILLER_83_478 vccd1 vssd1 vccd1 vssd1 sky130_ef_sc_hd__decap_12
X_3027_ _3028_/A _3028_/B _3028_/C vssd1 vssd1 vccd1 vccd1 _3027_/Y sky130_fd_sc_hd__a21oi_1
XANTENNA__2427__X _2427_/X vssd1 vssd1 vccd1 vccd1 sky130_fd_sc_hd__diode_2
XANTENNA_fanout359_A _3794_/A0 vssd1 vssd1 vccd1 vccd1 sky130_fd_sc_hd__diode_2
XFILLER_36_383 vssd1 vssd1 vccd1 vccd1 sky130_fd_sc_hd__fill_2
Xclkload4 clkload4/A vssd1 vssd1 vccd1 vccd1 clkload4/Y sky130_fd_sc_hd__inv_6
X_3929_ _3872_/X _3971_/A1 _3985_/D vssd1 vssd1 vccd1 vccd1 _3929_/X sky130_fd_sc_hd__mux2_1
XANTENNA_fanout314_X _4352_/A vssd1 vssd1 vccd1 vccd1 sky130_fd_sc_hd__diode_2
XANTENNA__4798__Q _4798_/Q vssd1 vssd1 vccd1 vccd1 sky130_fd_sc_hd__diode_2
XFILLER_3_438 vssd1 vssd1 vccd1 vccd1 sky130_fd_sc_hd__decap_8
XFILLER_3_449 vccd1 vssd1 vccd1 vssd1 sky130_ef_sc_hd__decap_12
Xfanout230 _3904_/X vssd1 vssd1 vccd1 vccd1 _4022_/A2 sky130_fd_sc_hd__clkbuf_4
XTAP_TAPCELL_ROW_6_243 vssd1 vccd1 sky130_fd_sc_hd__tapvpwrvgnd_1
Xfanout241 _2232_/X vssd1 vssd1 vccd1 vccd1 _2250_/S sky130_fd_sc_hd__clkbuf_2
Xfanout263 _4306_/C vssd1 vssd1 vccd1 vccd1 _4302_/C sky130_fd_sc_hd__clkbuf_2
Xfanout274 _4812_/Q vssd1 vssd1 vccd1 vccd1 _4175_/B sky130_fd_sc_hd__dlymetal6s2s_1
Xfanout252 _2205_/Y vssd1 vssd1 vccd1 vccd1 _2335_/C sky130_fd_sc_hd__buf_2
Xfanout296 _4803_/Q vssd1 vssd1 vccd1 vccd1 _4374_/S sky130_fd_sc_hd__clkbuf_2
Xfanout285 _4009_/A_N vssd1 vssd1 vccd1 vccd1 _3976_/D sky130_fd_sc_hd__clkbuf_2
XTAP_TAPCELL_ROW_85_952 vssd1 vccd1 sky130_fd_sc_hd__tapvpwrvgnd_1
XFILLER_27_361 vccd1 vssd1 vccd1 vssd1 sky130_ef_sc_hd__decap_12
XFILLER_54_180 vssd1 vssd1 vccd1 vccd1 sky130_fd_sc_hd__fill_2
XTAP_TAPCELL_ROW_57_698 vssd1 vccd1 sky130_fd_sc_hd__tapvpwrvgnd_1
XFILLER_42_386 vssd1 vssd1 vccd1 vccd1 sky130_fd_sc_hd__decap_6
XANTENNA__4337__B1 _4376_/A2 vssd1 vssd1 vccd1 vccd1 sky130_fd_sc_hd__diode_2
XFILLER_6_298 vssd1 vssd1 vccd1 vccd1 sky130_fd_sc_hd__decap_4
X_2260_ hold62/X _4568_/Q _2270_/S vssd1 vssd1 vccd1 vccd1 _4439_/D sky130_fd_sc_hd__mux2_1
XFILLER_37_103 vssd1 vssd1 vccd1 vccd1 sky130_fd_sc_hd__fill_1
XFILLER_65_445 vssd1 vssd1 vccd1 vccd1 sky130_fd_sc_hd__decap_3
XFILLER_1_42 vccd1 vssd1 vccd1 vssd1 sky130_ef_sc_hd__decap_12
XFILLER_37_147 vssd1 vssd1 vccd1 vccd1 sky130_fd_sc_hd__decap_8
XTAP_TAPCELL_ROW_48_621 vssd1 vccd1 sky130_fd_sc_hd__tapvpwrvgnd_1
XFILLER_37_169 vssd1 vssd1 vccd1 vccd1 sky130_fd_sc_hd__decap_4
XANTENNA__3615__A2 _3613_/B vssd1 vssd1 vccd1 vccd1 sky130_fd_sc_hd__diode_2
XFILLER_33_386 vssd1 vssd1 vccd1 vccd1 sky130_fd_sc_hd__decap_4
XFILLER_60_172 vssd1 vssd1 vccd1 vccd1 sky130_fd_sc_hd__decap_3
X_4763_ _4771_/CLK _4763_/D fanout400/X vssd1 vssd1 vccd1 vccd1 _4763_/Q sky130_fd_sc_hd__dfrtp_1
XANTENNA__4040__A2 _3976_/D vssd1 vssd1 vccd1 vccd1 sky130_fd_sc_hd__diode_2
X_4694_ clkload8/A _4694_/D fanout386/X vssd1 vssd1 vccd1 vccd1 hold94/A sky130_fd_sc_hd__dfrtp_1
X_3714_ _4530_/Q _4639_/Q vssd1 vssd1 vccd1 vccd1 _3716_/A sky130_fd_sc_hd__nor2_1
XANTENNA__4060__D _4123_/S vssd1 vssd1 vccd1 vccd1 sky130_fd_sc_hd__diode_2
X_3645_ _4521_/Q _4630_/Q vssd1 vssd1 vccd1 vccd1 _3647_/A sky130_fd_sc_hd__and2_1
X_3576_ _3573_/X _3574_/Y _3549_/A _3575_/X vssd1 vssd1 vccd1 vccd1 _4587_/D sky130_fd_sc_hd__a31o_1
X_2527_ _2528_/A _2528_/B _2528_/C vssd1 vssd1 vccd1 vccd1 _2560_/A sky130_fd_sc_hd__a21oi_1
X_2458_ _2456_/Y _2458_/B vssd1 vssd1 vccd1 vccd1 _2459_/B sky130_fd_sc_hd__and2b_1
Xhold16 hold16/A vssd1 vssd1 vccd1 vccd1 hold16/X sky130_fd_sc_hd__dlygate4sd3_1
Xhold27 hold27/A vssd1 vssd1 vccd1 vccd1 hold27/X sky130_fd_sc_hd__dlygate4sd3_1
Xhold38 hold38/A vssd1 vssd1 vccd1 vccd1 hold38/X sky130_fd_sc_hd__dlygate4sd3_1
Xhold49 hold49/A vssd1 vssd1 vccd1 vccd1 hold49/X sky130_fd_sc_hd__dlygate4sd3_1
XTAP_TAPCELL_ROW_3_213 vssd1 vccd1 sky130_fd_sc_hd__tapvpwrvgnd_1
X_2389_ _4562_/Q hold54/A _2425_/S vssd1 vssd1 vccd1 vccd1 _2389_/X sky130_fd_sc_hd__mux2_1
X_4128_ _4140_/A_N _4136_/B _4132_/C _4323_/S vssd1 vssd1 vccd1 vccd1 _4128_/X sky130_fd_sc_hd__and4b_1
X_4059_ _4099_/A0 _4083_/A1 _4064_/D vssd1 vssd1 vccd1 vccd1 _4059_/X sky130_fd_sc_hd__mux2_1
XANTENNA__4235__D _4239_/D vssd1 vssd1 vccd1 vccd1 sky130_fd_sc_hd__diode_2
XTAP_TAPCELL_ROW_54_679 vssd1 vccd1 sky130_fd_sc_hd__tapvpwrvgnd_1
XANTENNA__2290__A1 _2310_/A1 vssd1 vssd1 vccd1 vccd1 sky130_fd_sc_hd__diode_2
XFILLER_3_279 vssd1 vssd1 vccd1 vccd1 sky130_fd_sc_hd__fill_1
XFILLER_86_77 vssd1 vssd1 vccd1 vccd1 sky130_fd_sc_hd__decap_6
XFILLER_19_125 vssd1 vssd1 vccd1 vccd1 sky130_fd_sc_hd__decap_8
XFILLER_74_264 vssd1 vssd1 vccd1 vccd1 sky130_fd_sc_hd__decap_4
XFILLER_74_253 vssd1 vssd1 vccd1 vccd1 sky130_fd_sc_hd__fill_2
XFILLER_19_169 vssd1 vssd1 vccd1 vccd1 sky130_fd_sc_hd__decap_8
XANTENNA__2281__A1 _2310_/A1 vssd1 vssd1 vccd1 vccd1 sky130_fd_sc_hd__diode_2
XFILLER_42_172 vssd1 vssd1 vccd1 vccd1 sky130_fd_sc_hd__decap_3
XANTENNA__4022__A2 _4022_/A2 vssd1 vssd1 vccd1 vccd1 sky130_fd_sc_hd__diode_2
X_3430_ _4558_/Q _3162_/Y _3428_/X _3429_/X vssd1 vssd1 vccd1 vccd1 _4558_/D sky130_fd_sc_hd__a22o_1
XANTENNA__4325__A3 _4328_/B vssd1 vssd1 vccd1 vccd1 sky130_fd_sc_hd__diode_2
X_3361_ _3361_/A _3361_/B vssd1 vssd1 vccd1 vccd1 _3361_/X sky130_fd_sc_hd__or2_1
X_2312_ _4071_/S _2335_/C _2335_/B _3886_/S _2311_/Y vssd1 vssd1 vccd1 vccd1 _2312_/X
+ sky130_fd_sc_hd__a311o_1
XFILLER_32_3 vssd1 vssd1 vccd1 vccd1 sky130_fd_sc_hd__fill_1
X_3292_ _4557_/Q _4598_/Q vssd1 vssd1 vccd1 vccd1 _3294_/B sky130_fd_sc_hd__xnor2_1
XANTENNA__4089__A2 _4105_/A2 vssd1 vssd1 vccd1 vccd1 sky130_fd_sc_hd__diode_2
X_2243_ hold27/X _4551_/Q _2249_/S vssd1 vssd1 vccd1 vccd1 _4422_/D sky130_fd_sc_hd__mux2_1
XFILLER_65_275 vssd1 vssd1 vccd1 vccd1 sky130_fd_sc_hd__decap_4
XFILLER_65_253 vssd1 vssd1 vccd1 vccd1 sky130_fd_sc_hd__fill_2
XFILLER_80_289 vccd1 vssd1 vccd1 vssd1 sky130_ef_sc_hd__decap_12
XFILLER_33_150 vssd1 vssd1 vccd1 vccd1 sky130_fd_sc_hd__decap_6
XFILLER_33_161 vssd1 vssd1 vccd1 vccd1 sky130_fd_sc_hd__fill_1
XFILLER_40_109 vssd1 vssd1 vccd1 vccd1 sky130_fd_sc_hd__decap_3
X_4815_ _4815_/CLK _4815_/D fanout395/X vssd1 vssd1 vccd1 vccd1 _4815_/Q sky130_fd_sc_hd__dfrtp_1
XTAP_TAPCELL_ROW_51_649 vssd1 vccd1 sky130_fd_sc_hd__tapvpwrvgnd_1
X_4746_ _4748_/CLK _4746_/D fanout390/X vssd1 vssd1 vccd1 vccd1 _4746_/Q sky130_fd_sc_hd__dfrtp_1
X_4677_ _4686_/CLK _4677_/D fanout385/X vssd1 vssd1 vccd1 vccd1 _4677_/Q sky130_fd_sc_hd__dfrtp_1
X_3628_ _3628_/A vssd1 vssd1 vccd1 vccd1 _3628_/Y sky130_fd_sc_hd__inv_2
Xoutput39 hold7/A vssd1 vssd1 vccd1 vccd1 m_axis_tdata[11] sky130_fd_sc_hd__buf_2
X_3559_ _3558_/A _3553_/Y _3558_/B vssd1 vssd1 vccd1 vccd1 _3567_/B sky130_fd_sc_hd__o21ai_1
XFILLER_0_249 vssd1 vssd1 vccd1 vccd1 sky130_fd_sc_hd__decap_3
XFILLER_29_412 vssd1 vssd1 vccd1 vccd1 sky130_fd_sc_hd__fill_1
XTAP_TAPCELL_ROW_59_716 vssd1 vccd1 sky130_fd_sc_hd__tapvpwrvgnd_1
XFILLER_56_25 vssd1 vssd1 vccd1 vccd1 sky130_fd_sc_hd__fill_1
XFILLER_29_478 vssd1 vssd1 vccd1 vccd1 sky130_fd_sc_hd__decap_4
XFILLER_56_253 vssd1 vssd1 vccd1 vccd1 sky130_fd_sc_hd__decap_6
XFILLER_56_264 vccd1 vssd1 vccd1 vssd1 sky130_ef_sc_hd__decap_12
XTAP_TAPCELL_ROW_67_793 vssd1 vccd1 sky130_fd_sc_hd__tapvpwrvgnd_1
XFILLER_44_459 vssd1 vssd1 vccd1 vccd1 sky130_fd_sc_hd__decap_8
XTAP_TAPCELL_ROW_14_318 vssd1 vccd1 sky130_fd_sc_hd__tapvpwrvgnd_1
XANTENNA__3460__B1 _3460_/B1 vssd1 vssd1 vccd1 vccd1 sky130_fd_sc_hd__diode_2
XTAP_TAPCELL_ROW_22_384 vssd1 vccd1 sky130_fd_sc_hd__tapvpwrvgnd_1
XFILLER_21_61 vssd1 vssd1 vccd1 vccd1 sky130_fd_sc_hd__fill_1
XFILLER_79_389 vssd1 vssd1 vccd1 vccd1 sky130_fd_sc_hd__decap_3
XANTENNA_clkload2_A clkload2/A vssd1 vssd1 vccd1 vccd1 sky130_fd_sc_hd__diode_2
XFILLER_47_286 vssd1 vssd1 vccd1 vccd1 sky130_fd_sc_hd__fill_1
X_2930_ _4529_/Q _2930_/A2 _2915_/X _2929_/Y vssd1 vssd1 vccd1 vccd1 _4529_/D sky130_fd_sc_hd__o22a_1
X_4600_ _4635_/CLK _4600_/D fanout426/X vssd1 vssd1 vccd1 vccd1 _4600_/Q sky130_fd_sc_hd__dfrtp_1
X_2861_ _2861_/A _2861_/B _2861_/C vssd1 vssd1 vccd1 vccd1 _2864_/A sky130_fd_sc_hd__and3_1
XFILLER_30_197 vssd1 vssd1 vccd1 vccd1 sky130_fd_sc_hd__decap_8
X_2792_ _2793_/B _2793_/A vssd1 vssd1 vccd1 vccd1 _2792_/Y sky130_fd_sc_hd__nor2_1
X_4531_ _4640_/CLK _4531_/D fanout427/X vssd1 vssd1 vccd1 vccd1 _4531_/Q sky130_fd_sc_hd__dfrtp_1
XFILLER_7_393 vccd1 vssd1 vccd1 vssd1 sky130_ef_sc_hd__decap_12
X_4462_ _4686_/CLK _4462_/D fanout386/X vssd1 vssd1 vccd1 vccd1 _4462_/Q sky130_fd_sc_hd__dfrtp_1
X_3413_ _3423_/A1 _3410_/Y _3412_/Y _3423_/B1 vssd1 vssd1 vccd1 vccd1 _3413_/X sky130_fd_sc_hd__a31o_1
X_4393_ _4371_/A input8/X _4406_/S vssd1 vssd1 vccd1 vccd1 _4802_/D sky130_fd_sc_hd__mux2_1
X_3344_ _3266_/C _3261_/Y _3338_/A _3264_/Y vssd1 vssd1 vccd1 vccd1 _3345_/B sky130_fd_sc_hd__a211o_1
X_3275_ _3282_/A _4589_/Q _4588_/Q _4547_/Q vssd1 vssd1 vccd1 vccd1 _3275_/Y sky130_fd_sc_hd__a22oi_1
XFILLER_85_337 vccd1 vssd1 vccd1 vssd1 sky130_ef_sc_hd__decap_12
X_2226_ _4540_/Q _4539_/Q vssd1 vssd1 vccd1 vccd1 _2226_/X sky130_fd_sc_hd__or2_1
XFILLER_26_404 vssd1 vssd1 vccd1 vccd1 sky130_fd_sc_hd__decap_8
XFILLER_38_231 vssd1 vssd1 vccd1 vccd1 sky130_fd_sc_hd__decap_8
XFILLER_26_39 vccd1 vssd1 vccd1 vssd1 sky130_ef_sc_hd__decap_12
XFILLER_26_437 vccd1 vssd1 vccd1 vssd1 sky130_ef_sc_hd__decap_12
XTAP_TAPCELL_ROW_64_763 vssd1 vccd1 sky130_fd_sc_hd__tapvpwrvgnd_1
XFILLER_41_418 vssd1 vssd1 vccd1 vccd1 sky130_fd_sc_hd__decap_3
XANTENNA_fanout439_A fanout440/X vssd1 vssd1 vccd1 vccd1 sky130_fd_sc_hd__diode_2
XANTENNA__4195__A_N _4258_/C vssd1 vssd1 vccd1 vccd1 sky130_fd_sc_hd__diode_2
XANTENNA_fanout227_X _4173_/A2 vssd1 vssd1 vccd1 vccd1 sky130_fd_sc_hd__diode_2
XFILLER_21_197 vssd1 vssd1 vccd1 vccd1 sky130_fd_sc_hd__fill_2
X_4729_ _4744_/CLK _4729_/D fanout391/X vssd1 vssd1 vccd1 vccd1 _4729_/Q sky130_fd_sc_hd__dfrtp_1
XANTENNA_fanout87_A _3460_/B1 vssd1 vssd1 vccd1 vccd1 sky130_fd_sc_hd__diode_2
XFILLER_29_275 vssd1 vssd1 vccd1 vccd1 sky130_fd_sc_hd__decap_4
XTAP_TAPCELL_ROW_27_432 vssd1 vccd1 sky130_fd_sc_hd__tapvpwrvgnd_1
XFILLER_44_234 vccd1 vssd1 vccd1 vssd1 sky130_ef_sc_hd__decap_12
XPHY_EDGE_ROW_17_Left_105 vssd1 vssd1 vccd1 vccd1 sky130_fd_sc_hd__decap_3
XANTENNA__3984__A1 _4020_/A1 vssd1 vssd1 vccd1 vccd1 sky130_fd_sc_hd__diode_2
XANTENNA__3433__B1 _3460_/B1 vssd1 vssd1 vccd1 vccd1 sky130_fd_sc_hd__diode_2
XFILLER_12_175 vssd1 vssd1 vccd1 vccd1 sky130_fd_sc_hd__decap_3
XPHY_EDGE_ROW_26_Left_114 vssd1 vssd1 vccd1 vccd1 sky130_fd_sc_hd__decap_3
XANTENNA__4161__A1 _4227_/C vssd1 vssd1 vccd1 vccd1 sky130_fd_sc_hd__diode_2
XFILLER_67_304 vssd1 vssd1 vccd1 vccd1 sky130_fd_sc_hd__fill_1
X_3060_ _4767_/Q _4782_/Q _3150_/A vssd1 vssd1 vccd1 vccd1 _3063_/B sky130_fd_sc_hd__a21o_1
XFILLER_67_337 vssd1 vssd1 vccd1 vccd1 sky130_fd_sc_hd__fill_2
XTAP_TAPCELL_ROW_78_888 vssd1 vccd1 sky130_fd_sc_hd__tapvpwrvgnd_1
XFILLER_75_370 vssd1 vssd1 vccd1 vccd1 sky130_fd_sc_hd__decap_4
XPHY_EDGE_ROW_35_Left_123 vssd1 vssd1 vccd1 vccd1 sky130_fd_sc_hd__decap_3
XFILLER_35_278 vssd1 vssd1 vccd1 vccd1 sky130_fd_sc_hd__fill_2
X_3962_ _4029_/D _3974_/A1 _4799_/Q _3899_/Y vssd1 vssd1 vccd1 vccd1 _3962_/X sky130_fd_sc_hd__o2bb2a_1
X_3893_ _4246_/B _4246_/C _4245_/D vssd1 vssd1 vccd1 vccd1 _3893_/X sky130_fd_sc_hd__and3_1
XFILLER_31_440 vssd1 vssd1 vccd1 vccd1 sky130_fd_sc_hd__decap_8
X_2913_ _2913_/A _2913_/B vssd1 vssd1 vccd1 vccd1 _2914_/B sky130_fd_sc_hd__nand2_1
X_2844_ _4746_/Q _4716_/Q vssd1 vssd1 vccd1 vccd1 _2845_/A sky130_fd_sc_hd__nor2_1
X_4514_ _4624_/CLK _4514_/D fanout407/X vssd1 vssd1 vccd1 vccd1 _4514_/Q sky130_fd_sc_hd__dfrtp_1
X_2775_ _2775_/A _2775_/B _2775_/C _2775_/D vssd1 vssd1 vccd1 vccd1 _2775_/Y sky130_fd_sc_hd__nor4_1
Xhold135 _4617_/Q vssd1 vssd1 vccd1 vccd1 hold135/X sky130_fd_sc_hd__dlygate4sd3_1
Xhold124 _4452_/Q vssd1 vssd1 vccd1 vccd1 hold124/X sky130_fd_sc_hd__dlygate4sd3_1
XPHY_EDGE_ROW_44_Left_132 vssd1 vssd1 vccd1 vccd1 sky130_fd_sc_hd__decap_3
Xhold113 _4711_/Q vssd1 vssd1 vccd1 vccd1 hold113/X sky130_fd_sc_hd__dlygate4sd3_1
Xhold102 _4741_/Q vssd1 vssd1 vccd1 vccd1 hold102/X sky130_fd_sc_hd__dlygate4sd3_1
X_4445_ _4577_/CLK _4445_/D fanout437/X vssd1 vssd1 vccd1 vccd1 hold50/A sky130_fd_sc_hd__dfrtp_1
Xhold157 _4690_/Q vssd1 vssd1 vccd1 vccd1 hold157/X sky130_fd_sc_hd__dlygate4sd3_1
Xhold146 _4691_/Q vssd1 vssd1 vccd1 vccd1 hold146/X sky130_fd_sc_hd__dlygate4sd3_1
Xhold168 _4677_/Q vssd1 vssd1 vccd1 vccd1 hold168/X sky130_fd_sc_hd__dlygate4sd3_1
X_4376_ hold131/X _4376_/A2 _4375_/X vssd1 vssd1 vccd1 vccd1 _4786_/D sky130_fd_sc_hd__a21o_1
Xhold179 _4657_/Q vssd1 vssd1 vccd1 vccd1 hold179/X sky130_fd_sc_hd__dlygate4sd3_1
XTAP_TAPCELL_ROW_69_811 vssd1 vccd1 sky130_fd_sc_hd__tapvpwrvgnd_1
X_3327_ _4579_/Q _3333_/B vssd1 vssd1 vccd1 vccd1 _3327_/Y sky130_fd_sc_hd__nand2_1
XANTENNA_fanout291_A _4033_/C vssd1 vssd1 vccd1 vccd1 sky130_fd_sc_hd__diode_2
XFILLER_85_167 vssd1 vssd1 vccd1 vccd1 sky130_fd_sc_hd__fill_1
X_3258_ _4544_/Q _4585_/Q vssd1 vssd1 vccd1 vccd1 _3258_/X sky130_fd_sc_hd__and2_1
X_3189_ _4572_/Q _3308_/B _4612_/Q _4571_/Q vssd1 vssd1 vccd1 vccd1 _3191_/B sky130_fd_sc_hd__o211a_1
X_2209_ _4512_/Q vssd1 vssd1 vccd1 vccd1 _3572_/A sky130_fd_sc_hd__inv_2
XPHY_EDGE_ROW_53_Left_141 vssd1 vssd1 vccd1 vccd1 sky130_fd_sc_hd__decap_3
XFILLER_81_373 vssd1 vssd1 vccd1 vccd1 sky130_fd_sc_hd__decap_8
XTAP_TAPCELL_ROW_24_402 vssd1 vccd1 sky130_fd_sc_hd__tapvpwrvgnd_1
XFILLER_26_267 vssd1 vssd1 vccd1 vccd1 sky130_fd_sc_hd__decap_3
XFILLER_41_204 vssd1 vssd1 vccd1 vccd1 sky130_fd_sc_hd__fill_2
XANTENNA_fanout344_X _4320_/A vssd1 vssd1 vccd1 vccd1 sky130_fd_sc_hd__diode_2
XFILLER_22_440 vssd1 vssd1 vccd1 vccd1 sky130_fd_sc_hd__fill_2
XPHY_EDGE_ROW_62_Left_150 vssd1 vssd1 vccd1 vccd1 sky130_fd_sc_hd__decap_3
XFILLER_5_127 vssd1 vssd1 vccd1 vccd1 sky130_fd_sc_hd__fill_1
XFILLER_5_105 vssd1 vssd1 vccd1 vccd1 sky130_fd_sc_hd__fill_2
XANTENNA__4032__S _4037_/D vssd1 vssd1 vccd1 vccd1 sky130_fd_sc_hd__diode_2
XFILLER_5_149 vssd1 vssd1 vccd1 vccd1 sky130_fd_sc_hd__decap_4
XFILLER_1_322 vssd1 vssd1 vccd1 vccd1 sky130_fd_sc_hd__decap_3
XANTENNA__4143__A1 _4167_/A1 vssd1 vssd1 vccd1 vccd1 sky130_fd_sc_hd__diode_2
XFILLER_76_112 vssd1 vssd1 vccd1 vccd1 sky130_fd_sc_hd__fill_2
XFILLER_49_326 vssd1 vssd1 vccd1 vccd1 sky130_fd_sc_hd__decap_8
XFILLER_49_337 vccd1 vssd1 vccd1 vssd1 sky130_ef_sc_hd__decap_12
XFILLER_17_201 vccd1 vssd1 vccd1 vssd1 sky130_ef_sc_hd__decap_12
XFILLER_17_278 vssd1 vssd1 vccd1 vccd1 sky130_fd_sc_hd__fill_2
Xclkbuf_2_0__f_clk clkbuf_0_clk/X vssd1 vssd1 vccd1 vccd1 clkload0/A sky130_fd_sc_hd__clkbuf_16
XFILLER_32_204 vssd1 vssd1 vccd1 vccd1 sky130_fd_sc_hd__fill_2
XFILLER_13_440 vssd1 vssd1 vccd1 vccd1 sky130_fd_sc_hd__fill_2
XFILLER_64_6 vssd1 vssd1 vccd1 vccd1 sky130_fd_sc_hd__fill_1
X_2560_ _2560_/A _2560_/B vssd1 vssd1 vccd1 vccd1 _2560_/Y sky130_fd_sc_hd__xnor2_1
X_2491_ _2471_/Y _2489_/B _2490_/X vssd1 vssd1 vccd1 vccd1 _2491_/Y sky130_fd_sc_hd__o21ai_1
X_4230_ _4238_/A0 _4238_/A1 _4368_/A vssd1 vssd1 vccd1 vccd1 _4230_/X sky130_fd_sc_hd__mux2_1
X_4161_ _4227_/C _4176_/A2 _4225_/B2 vssd1 vssd1 vccd1 vccd1 _4161_/Y sky130_fd_sc_hd__o21ai_1
X_3112_ _3112_/A _3112_/B _3112_/C vssd1 vssd1 vccd1 vccd1 _3114_/A sky130_fd_sc_hd__nor3_1
X_4092_ _4168_/C _4104_/B _4100_/C _4227_/C vssd1 vssd1 vccd1 vccd1 _4092_/X sky130_fd_sc_hd__and4b_1
X_3043_ _4533_/Q _3157_/A2 _3027_/Y _3042_/Y vssd1 vssd1 vccd1 vccd1 _4533_/D sky130_fd_sc_hd__o22a_1
XFILLER_67_178 vssd1 vssd1 vccd1 vccd1 sky130_fd_sc_hd__fill_1
XTAP_TAPCELL_ROW_38_527 vssd1 vccd1 sky130_fd_sc_hd__tapvpwrvgnd_1
XANTENNA__3948__A1 _2311_/A vssd1 vssd1 vccd1 vccd1 sky130_fd_sc_hd__diode_2
X_3945_ _4063_/S _3900_/X _3900_/B _4675_/Q vssd1 vssd1 vccd1 vccd1 _3945_/X sky130_fd_sc_hd__a2bb2o_1
X_3876_ _4808_/Q _4037_/C vssd1 vssd1 vccd1 vccd1 _3977_/B sky130_fd_sc_hd__or2_1
X_2827_ _2827_/A _2827_/B vssd1 vssd1 vccd1 vccd1 _2828_/A sky130_fd_sc_hd__nor2_1
XANTENNA_fanout304_A _4364_/A vssd1 vssd1 vccd1 vccd1 sky130_fd_sc_hd__diode_2
X_2758_ _2758_/A _2758_/B _2758_/C vssd1 vssd1 vccd1 vccd1 _2760_/A sky130_fd_sc_hd__and3_1
XANTENNA__4125__A1 _4324_/A vssd1 vssd1 vccd1 vccd1 sky130_fd_sc_hd__diode_2
X_2689_ _2689_/A _2689_/B vssd1 vssd1 vccd1 vccd1 _3823_/A sky130_fd_sc_hd__nor2_1
X_4428_ _4668_/CLK _4428_/D _2229_/B vssd1 vssd1 vccd1 vccd1 hold10/A sky130_fd_sc_hd__dfrtp_1
Xfanout423 fanout424/X vssd1 vssd1 vccd1 vccd1 fanout423/X sky130_fd_sc_hd__buf_2
Xfanout412 fanout413/X vssd1 vssd1 vccd1 vccd1 fanout412/X sky130_fd_sc_hd__clkbuf_4
Xfanout401 fanout404/X vssd1 vssd1 vccd1 vccd1 fanout401/X sky130_fd_sc_hd__dlymetal6s2s_1
XFILLER_86_421 vssd1 vssd1 vccd1 vccd1 sky130_fd_sc_hd__decap_8
X_4359_ _4374_/A0 _4374_/A1 _4364_/A vssd1 vssd1 vccd1 vccd1 _4359_/X sky130_fd_sc_hd__mux2_1
XANTENNA__3884__B1 _4199_/D vssd1 vssd1 vccd1 vccd1 sky130_fd_sc_hd__diode_2
Xfanout434 fanout435/X vssd1 vssd1 vccd1 vccd1 fanout434/X sky130_fd_sc_hd__buf_1
XFILLER_81_181 vccd1 vssd1 vccd1 vssd1 sky130_ef_sc_hd__decap_12
XTAP_TAPCELL_ROW_72_839 vssd1 vccd1 sky130_fd_sc_hd__tapvpwrvgnd_1
XTAP_TAPCELL_ROW_1_196 vssd1 vccd1 sky130_fd_sc_hd__tapvpwrvgnd_1
XFILLER_80_24 vssd1 vssd1 vccd1 vccd1 sky130_fd_sc_hd__fill_1
XFILLER_22_270 vccd1 vssd1 vccd1 vssd1 sky130_ef_sc_hd__decap_12
XFILLER_10_421 vssd1 vssd1 vccd1 vccd1 sky130_fd_sc_hd__fill_1
Xfanout96 _3655_/S vssd1 vssd1 vccd1 vccd1 _3603_/S sky130_fd_sc_hd__buf_2
Xfanout85 _3332_/Y vssd1 vssd1 vccd1 vccd1 _3423_/B1 sky130_fd_sc_hd__buf_2
XTAP_TAPCELL_ROW_9_274 vssd1 vccd1 sky130_fd_sc_hd__tapvpwrvgnd_1
XFILLER_37_318 vccd1 vssd1 vccd1 vssd1 sky130_ef_sc_hd__decap_12
XANTENNA__4148__D _4215_/C vssd1 vssd1 vccd1 vccd1 sky130_fd_sc_hd__diode_2
XTAP_TAPCELL_ROW_35_508 vssd1 vccd1 sky130_fd_sc_hd__tapvpwrvgnd_1
XFILLER_60_343 vccd1 vssd1 vccd1 vssd1 sky130_ef_sc_hd__decap_12
XTAP_TAPCELL_ROW_43_574 vssd1 vccd1 sky130_fd_sc_hd__tapvpwrvgnd_1
X_3730_ _4530_/Q _4639_/Q _4529_/Q _4638_/Q vssd1 vssd1 vccd1 vccd1 _3730_/X sky130_fd_sc_hd__o211a_1
XFILLER_60_376 vssd1 vssd1 vccd1 vccd1 sky130_fd_sc_hd__decap_4
XFILLER_13_281 vssd1 vssd1 vccd1 vccd1 sky130_fd_sc_hd__decap_3
XFILLER_9_274 vssd1 vssd1 vccd1 vccd1 sky130_fd_sc_hd__decap_6
X_3661_ _3661_/A _3661_/B vssd1 vssd1 vccd1 vccd1 _3664_/A sky130_fd_sc_hd__nand2_1
Xclkload44 _4575_/CLK vssd1 vssd1 vccd1 vccd1 clkload44/Y sky130_fd_sc_hd__bufinv_16
Xclkload22 _4817_/CLK vssd1 vssd1 vccd1 vccd1 clkload22/Y sky130_fd_sc_hd__inv_4
XFILLER_62_3 vccd1 vssd1 vccd1 vssd1 sky130_ef_sc_hd__decap_12
Xclkload33 _4587_/CLK vssd1 vssd1 vccd1 vccd1 clkload33/Y sky130_fd_sc_hd__bufinv_16
Xclkload11 _4686_/CLK vssd1 vssd1 vccd1 vccd1 clkload11/Y sky130_fd_sc_hd__clkinvlp_4
X_3592_ _3589_/X _3591_/X _4589_/Q _3655_/S vssd1 vssd1 vccd1 vccd1 _4589_/D sky130_fd_sc_hd__a2bb2o_1
X_2612_ _2612_/A _2612_/B vssd1 vssd1 vccd1 vccd1 _2613_/B sky130_fd_sc_hd__or2_1
X_2543_ _4692_/Q _4679_/Q vssd1 vssd1 vccd1 vccd1 _2543_/X sky130_fd_sc_hd__and2_1
XANTENNA__4107__B2 _4036_/S vssd1 vssd1 vccd1 vccd1 sky130_fd_sc_hd__diode_2
X_2474_ _2474_/A _2474_/B vssd1 vssd1 vccd1 vccd1 _2474_/Y sky130_fd_sc_hd__nand2_1
X_4213_ _4212_/Y _4211_/X _4210_/X hold95/X _4224_/B1 vssd1 vssd1 vccd1 vccd1 _4745_/D
+ sky130_fd_sc_hd__o32a_1
X_4144_ _4239_/D _4175_/B _4148_/C _4273_/S vssd1 vssd1 vccd1 vccd1 _4144_/X sky130_fd_sc_hd__and4b_1
XFILLER_68_498 vssd1 vssd1 vccd1 vccd1 sky130_fd_sc_hd__fill_1
XFILLER_55_104 vssd1 vssd1 vccd1 vccd1 sky130_fd_sc_hd__fill_1
X_4075_ _4103_/A0 _4103_/A1 _4075_/S vssd1 vssd1 vccd1 vccd1 _4075_/X sky130_fd_sc_hd__mux2_1
XFILLER_55_126 vssd1 vssd1 vccd1 vccd1 sky130_fd_sc_hd__decap_4
XFILLER_55_148 vssd1 vssd1 vccd1 vccd1 sky130_fd_sc_hd__decap_3
X_3026_ _3026_/A _3026_/B vssd1 vssd1 vccd1 vccd1 _3028_/C sky130_fd_sc_hd__xnor2_1
XFILLER_36_362 vssd1 vssd1 vccd1 vccd1 sky130_fd_sc_hd__fill_2
XFILLER_55_159 vssd1 vssd1 vccd1 vccd1 sky130_fd_sc_hd__decap_8
XFILLER_36_395 vssd1 vssd1 vccd1 vccd1 sky130_fd_sc_hd__decap_3
X_3928_ _3927_/X hold86/X _3928_/S vssd1 vssd1 vccd1 vccd1 _4669_/D sky130_fd_sc_hd__mux2_1
Xclkload5 clkload5/A vssd1 vssd1 vccd1 vccd1 clkload5/Y sky130_fd_sc_hd__inv_8
X_3859_ _3025_/A _3049_/Y _3150_/B _2919_/X _3050_/C vssd1 vssd1 vccd1 vccd1 _3859_/X
+ sky130_fd_sc_hd__o221a_1
XFILLER_50_27 vssd1 vssd1 vccd1 vccd1 sky130_fd_sc_hd__fill_1
XFILLER_50_38 vssd1 vssd1 vccd1 vccd1 sky130_fd_sc_hd__fill_1
XANTENNA_fanout307_X _4087_/S vssd1 vssd1 vccd1 vccd1 sky130_fd_sc_hd__diode_2
XFILLER_59_14 vssd1 vssd1 vccd1 vccd1 sky130_fd_sc_hd__fill_1
XFILLER_1_7 vssd1 vssd1 vccd1 vccd1 sky130_fd_sc_hd__decap_8
XTAP_TAPCELL_ROW_6_244 vssd1 vccd1 sky130_fd_sc_hd__tapvpwrvgnd_1
Xfanout220 _3926_/X vssd1 vssd1 vccd1 vccd1 _3971_/A1 sky130_fd_sc_hd__buf_2
Xfanout231 _3904_/X vssd1 vssd1 vccd1 vccd1 _4038_/A2 sky130_fd_sc_hd__buf_2
XFILLER_59_410 vssd1 vssd1 vccd1 vccd1 sky130_fd_sc_hd__fill_1
Xfanout264 _4815_/Q vssd1 vssd1 vccd1 vccd1 _4306_/C sky130_fd_sc_hd__dlymetal6s2s_1
Xfanout253 _4278_/A_N vssd1 vssd1 vccd1 vccd1 _4286_/A_N sky130_fd_sc_hd__clkbuf_2
Xfanout242 fanout248/X vssd1 vssd1 vccd1 vccd1 _2369_/S sky130_fd_sc_hd__buf_2
XFILLER_75_35 vssd1 vssd1 vccd1 vccd1 sky130_fd_sc_hd__decap_8
Xfanout297 _4803_/Q vssd1 vssd1 vccd1 vccd1 _4036_/S sky130_fd_sc_hd__clkbuf_4
Xfanout275 _4120_/C vssd1 vssd1 vccd1 vccd1 _4116_/D sky130_fd_sc_hd__clkbuf_2
Xfanout286 _4104_/C vssd1 vssd1 vccd1 vccd1 _4100_/C sky130_fd_sc_hd__clkbuf_2
XTAP_TAPCELL_ROW_85_953 vssd1 vccd1 sky130_fd_sc_hd__tapvpwrvgnd_1
XFILLER_27_373 vccd1 vssd1 vccd1 vssd1 sky130_ef_sc_hd__decap_12
XTAP_TAPCELL_ROW_57_699 vssd1 vccd1 sky130_fd_sc_hd__tapvpwrvgnd_1
XFILLER_54_192 vssd1 vssd1 vccd1 vccd1 sky130_fd_sc_hd__decap_4
XANTENNA__4337__A1 _4203_/C vssd1 vssd1 vccd1 vccd1 sky130_fd_sc_hd__diode_2
XFILLER_37_115 vssd1 vssd1 vccd1 vccd1 sky130_fd_sc_hd__fill_1
XFILLER_1_54 vssd1 vssd1 vccd1 vccd1 sky130_fd_sc_hd__fill_2
XTAP_TAPCELL_ROW_48_622 vssd1 vccd1 sky130_fd_sc_hd__tapvpwrvgnd_1
XFILLER_18_362 vssd1 vssd1 vccd1 vccd1 sky130_fd_sc_hd__fill_2
XFILLER_33_343 vssd1 vssd1 vccd1 vccd1 sky130_fd_sc_hd__fill_1
XFILLER_21_505 vssd1 vssd1 vccd1 vccd1 sky130_fd_sc_hd__fill_1
X_4762_ _4776_/CLK _4762_/D fanout400/X vssd1 vssd1 vccd1 vccd1 _4762_/Q sky130_fd_sc_hd__dfrtp_1
X_4693_ clkload5/A _4693_/D fanout378/X vssd1 vssd1 vccd1 vccd1 _4693_/Q sky130_fd_sc_hd__dfrtp_1
X_3713_ _4604_/Q _3741_/S _3712_/X _3711_/Y vssd1 vssd1 vccd1 vccd1 _4604_/D sky130_fd_sc_hd__a22o_1
X_3644_ _3630_/Y _3656_/A _3642_/X vssd1 vssd1 vccd1 vccd1 _3648_/A sky130_fd_sc_hd__a21oi_1
XTAP_TAPCELL_ROW_11_290 vssd1 vccd1 sky130_fd_sc_hd__tapvpwrvgnd_1
XANTENNA__2339__B1 _3975_/S vssd1 vssd1 vccd1 vccd1 sky130_fd_sc_hd__diode_2
X_3575_ _3603_/S _4587_/Q vssd1 vssd1 vccd1 vccd1 _3575_/X sky130_fd_sc_hd__and2_1
X_2526_ _2528_/A _2528_/B vssd1 vssd1 vccd1 vccd1 _2526_/X sky130_fd_sc_hd__and2_1
X_2457_ _2470_/C _2456_/B _4455_/Q vssd1 vssd1 vccd1 vccd1 _2458_/B sky130_fd_sc_hd__o21bai_1
Xhold28 hold28/A vssd1 vssd1 vccd1 vccd1 hold28/X sky130_fd_sc_hd__dlygate4sd3_1
Xhold17 hold17/A vssd1 vssd1 vccd1 vccd1 hold17/X sky130_fd_sc_hd__dlygate4sd3_1
Xhold39 hold39/A vssd1 vssd1 vccd1 vccd1 hold39/X sky130_fd_sc_hd__dlygate4sd3_1
XTAP_TAPCELL_ROW_3_214 vssd1 vccd1 sky130_fd_sc_hd__tapvpwrvgnd_1
X_2388_ hold34/X _2387_/X _2426_/S vssd1 vssd1 vccd1 vccd1 _4489_/D sky130_fd_sc_hd__mux2_1
XFILLER_56_402 vccd1 vssd1 vccd1 vssd1 sky130_ef_sc_hd__decap_12
XFILLER_83_221 vssd1 vssd1 vccd1 vccd1 sky130_fd_sc_hd__decap_3
X_4127_ _4167_/A0 _4171_/A1 _4266_/D vssd1 vssd1 vccd1 vccd1 _4127_/X sky130_fd_sc_hd__mux2_1
X_4058_ _4057_/Y _4056_/X _4055_/X _4706_/Q _4058_/B2 vssd1 vssd1 vccd1 vccd1 _4706_/D
+ sky130_fd_sc_hd__o32a_1
XTAP_TAPCELL_ROW_82_923 vssd1 vccd1 sky130_fd_sc_hd__tapvpwrvgnd_1
X_3009_ _3009_/A _3009_/B vssd1 vssd1 vccd1 vccd1 _3028_/A sky130_fd_sc_hd__nand2_1
XFILLER_24_321 vssd1 vssd1 vccd1 vccd1 sky130_fd_sc_hd__fill_2
XFILLER_24_354 vssd1 vssd1 vccd1 vccd1 sky130_fd_sc_hd__fill_1
XANTENNA_fanout424_X fanout424/X vssd1 vssd1 vccd1 vccd1 sky130_fd_sc_hd__diode_2
XFILLER_3_203 vssd1 vssd1 vccd1 vccd1 sky130_fd_sc_hd__fill_1
XFILLER_79_505 vssd1 vssd1 vccd1 vccd1 sky130_fd_sc_hd__fill_1
XFILLER_74_210 vccd1 vssd1 vccd1 vssd1 sky130_ef_sc_hd__decap_12
XFILLER_47_457 vssd1 vssd1 vccd1 vccd1 sky130_fd_sc_hd__decap_3
XTAP_TAPCELL_ROW_17_338 vssd1 vccd1 sky130_fd_sc_hd__tapvpwrvgnd_1
XFILLER_30_324 vssd1 vssd1 vccd1 vccd1 sky130_fd_sc_hd__fill_2
X_3360_ _3359_/C _3359_/B _3359_/A vssd1 vssd1 vccd1 vccd1 _3361_/B sky130_fd_sc_hd__a21oi_1
X_2311_ _2311_/A _2323_/B vssd1 vssd1 vccd1 vccd1 _2311_/Y sky130_fd_sc_hd__nor2_1
X_3291_ _3437_/A _3432_/A _3427_/A vssd1 vssd1 vccd1 vccd1 _3294_/A sky130_fd_sc_hd__nand3_1
X_2242_ hold56/X _4550_/Q _2242_/S vssd1 vssd1 vccd1 vccd1 _4421_/D sky130_fd_sc_hd__mux2_1
XFILLER_25_3 vssd1 vssd1 vccd1 vccd1 sky130_fd_sc_hd__decap_8
XFILLER_38_468 vssd1 vssd1 vccd1 vccd1 sky130_fd_sc_hd__fill_1
Xclkbuf_leaf_45_clk clkload0/A vssd1 vssd1 vccd1 vccd1 clkload9/A sky130_fd_sc_hd__clkbuf_8
XFILLER_53_449 vccd1 vssd1 vccd1 vssd1 sky130_ef_sc_hd__decap_12
X_4814_ _4815_/CLK _4814_/D fanout394/X vssd1 vssd1 vccd1 vccd1 _4814_/Q sky130_fd_sc_hd__dfrtp_1
X_4745_ _4745_/CLK _4745_/D fanout390/X vssd1 vssd1 vccd1 vccd1 hold95/A sky130_fd_sc_hd__dfrtp_1
X_4676_ _4794_/CLK _4676_/D fanout377/X vssd1 vssd1 vccd1 vccd1 _4676_/Q sky130_fd_sc_hd__dfrtp_1
XANTENNA_fanout217_A _3543_/A vssd1 vssd1 vccd1 vccd1 sky130_fd_sc_hd__diode_2
X_3627_ _3627_/A _3627_/B _3627_/C vssd1 vssd1 vccd1 vccd1 _3628_/A sky130_fd_sc_hd__or3_1
X_3558_ _3558_/A _3558_/B vssd1 vssd1 vccd1 vccd1 _3558_/Y sky130_fd_sc_hd__nand2_1
XFILLER_0_206 vssd1 vssd1 vccd1 vccd1 sky130_fd_sc_hd__fill_1
X_2509_ _2502_/A _2502_/B _2508_/X vssd1 vssd1 vccd1 vccd1 _2509_/Y sky130_fd_sc_hd__o21ai_1
X_3489_ _4610_/Q _3503_/A2 _3504_/B1 _3784_/A1 vssd1 vssd1 vccd1 vccd1 _3489_/X sky130_fd_sc_hd__o211a_1
XTAP_TAPCELL_ROW_59_717 vssd1 vccd1 sky130_fd_sc_hd__tapvpwrvgnd_1
XTAP_TAPCELL_ROW_67_794 vssd1 vccd1 sky130_fd_sc_hd__tapvpwrvgnd_1
XFILLER_44_438 vssd1 vssd1 vccd1 vccd1 sky130_fd_sc_hd__fill_1
Xclkbuf_leaf_36_clk clkload2/A vssd1 vssd1 vccd1 vccd1 _4820_/CLK sky130_fd_sc_hd__clkbuf_8
XTAP_TAPCELL_ROW_14_319 vssd1 vccd1 sky130_fd_sc_hd__tapvpwrvgnd_1
XANTENNA__3460__A1 _3460_/A1 vssd1 vssd1 vccd1 vccd1 sky130_fd_sc_hd__diode_2
XFILLER_12_313 vssd1 vssd1 vccd1 vccd1 sky130_fd_sc_hd__decap_3
XFILLER_24_195 vssd1 vssd1 vccd1 vccd1 sky130_fd_sc_hd__fill_1
XFILLER_12_368 vccd1 vssd1 vccd1 vssd1 sky130_ef_sc_hd__decap_12
XANTENNA__3874__S _3928_/S vssd1 vssd1 vccd1 vccd1 sky130_fd_sc_hd__diode_2
XTAP_TAPCELL_ROW_22_385 vssd1 vccd1 sky130_fd_sc_hd__tapvpwrvgnd_1
XFILLER_4_501 vccd1 vssd1 vccd1 vssd1 sky130_ef_sc_hd__decap_12
XFILLER_79_324 vccd1 vssd1 vccd1 vssd1 sky130_ef_sc_hd__decap_12
XANTENNA__4156__D _4223_/C vssd1 vssd1 vccd1 vccd1 sky130_fd_sc_hd__diode_2
Xclkbuf_leaf_27_clk clkbuf_2_3__f_clk/X vssd1 vssd1 vccd1 vccd1 _4577_/CLK sky130_fd_sc_hd__clkbuf_8
X_2860_ _4759_/Q _4774_/Q _2820_/A _2823_/B _2858_/Y vssd1 vssd1 vccd1 vccd1 _2861_/C
+ sky130_fd_sc_hd__a311o_1
X_2791_ _2754_/A _2754_/C _2754_/B vssd1 vssd1 vccd1 vccd1 _2793_/B sky130_fd_sc_hd__a21boi_1
X_4530_ _4640_/CLK _4530_/D fanout425/X vssd1 vssd1 vccd1 vccd1 _4530_/Q sky130_fd_sc_hd__dfrtp_1
X_4461_ clkload8/A _4461_/D fanout381/X vssd1 vssd1 vccd1 vccd1 _4461_/Q sky130_fd_sc_hd__dfrtp_1
X_3412_ _3412_/A vssd1 vssd1 vccd1 vccd1 _3412_/Y sky130_fd_sc_hd__inv_2
X_4392_ _4368_/A input7/X _4408_/S vssd1 vssd1 vccd1 vccd1 _4801_/D sky130_fd_sc_hd__mux2_1
X_3343_ _3338_/A _3264_/Y _3266_/C _3261_/Y vssd1 vssd1 vccd1 vccd1 _3343_/X sky130_fd_sc_hd__o211a_1
X_3274_ _3282_/A _4589_/Q vssd1 vssd1 vccd1 vccd1 _3370_/C sky130_fd_sc_hd__nand2_1
XFILLER_85_349 vccd1 vssd1 vccd1 vssd1 sky130_ef_sc_hd__decap_12
X_2225_ _4579_/Q vssd1 vssd1 vccd1 vccd1 _3333_/D sky130_fd_sc_hd__inv_2
Xclkbuf_leaf_18_clk clkload1/A vssd1 vssd1 vccd1 vccd1 _4780_/CLK sky130_fd_sc_hd__clkbuf_8
XPHY_EDGE_ROW_5_Right_5 vssd1 vssd1 vccd1 vccd1 sky130_fd_sc_hd__decap_3
XFILLER_26_449 vssd1 vssd1 vccd1 vccd1 sky130_fd_sc_hd__decap_8
XTAP_TAPCELL_ROW_64_764 vssd1 vccd1 sky130_fd_sc_hd__tapvpwrvgnd_1
XANTENNA_fanout334_A _4328_/A vssd1 vssd1 vccd1 vccd1 sky130_fd_sc_hd__diode_2
X_2989_ _2873_/A _3862_/B _3033_/B _2988_/B vssd1 vssd1 vccd1 vccd1 _2989_/X sky130_fd_sc_hd__o2bb2a_1
X_4728_ _4744_/CLK _4728_/D fanout389/X vssd1 vssd1 vccd1 vccd1 _4728_/Q sky130_fd_sc_hd__dfrtp_1
X_4659_ _4669_/CLK _4659_/D fanout406/X vssd1 vssd1 vccd1 vccd1 _4659_/Q sky130_fd_sc_hd__dfrtp_1
XFILLER_76_305 vssd1 vssd1 vccd1 vccd1 sky130_fd_sc_hd__decap_3
XFILLER_83_57 vssd1 vssd1 vccd1 vccd1 sky130_fd_sc_hd__fill_2
XTAP_TAPCELL_ROW_27_433 vssd1 vccd1 sky130_fd_sc_hd__tapvpwrvgnd_1
XFILLER_44_246 vssd1 vssd1 vccd1 vccd1 sky130_fd_sc_hd__fill_1
XANTENNA__3433__A1 _3460_/A1 vssd1 vssd1 vccd1 vccd1 sky130_fd_sc_hd__diode_2
XFILLER_8_158 vssd1 vssd1 vccd1 vccd1 sky130_fd_sc_hd__fill_1
XFILLER_32_72 vccd1 vssd1 vccd1 vssd1 sky130_ef_sc_hd__decap_12
XANTENNA__4811__RESET_B fanout379/X vssd1 vssd1 vccd1 vccd1 sky130_fd_sc_hd__diode_2
XFILLER_4_353 vssd1 vssd1 vccd1 vccd1 sky130_fd_sc_hd__decap_8
XFILLER_79_110 vssd1 vssd1 vccd1 vccd1 sky130_fd_sc_hd__fill_2
XANTENNA__4161__A2 _4176_/A2 vssd1 vssd1 vccd1 vccd1 sky130_fd_sc_hd__diode_2
XFILLER_79_165 vssd1 vssd1 vccd1 vccd1 sky130_fd_sc_hd__fill_1
XTAP_TAPCELL_ROW_78_889 vssd1 vccd1 sky130_fd_sc_hd__tapvpwrvgnd_1
X_3961_ hold181/X _4130_/B1 _3960_/X vssd1 vssd1 vccd1 vccd1 _4680_/D sky130_fd_sc_hd__o21ba_1
XANTENNA__4183__B _4211_/B vssd1 vssd1 vccd1 vccd1 sky130_fd_sc_hd__diode_2
X_2912_ _2911_/C _2911_/A _2911_/B vssd1 vssd1 vccd1 vccd1 _2913_/B sky130_fd_sc_hd__o21ai_2
XTAP_TAPCELL_ROW_61_734 vssd1 vccd1 sky130_fd_sc_hd__tapvpwrvgnd_1
X_3892_ _4306_/B _4306_/C vssd1 vssd1 vccd1 vccd1 _4246_/C sky130_fd_sc_hd__nand2_1
XFILLER_31_430 vssd1 vssd1 vccd1 vccd1 sky130_fd_sc_hd__decap_4
X_2843_ _4746_/Q _4716_/Q vssd1 vssd1 vccd1 vccd1 _2845_/C sky130_fd_sc_hd__and2_1
XANTENNA__4403__S _4408_/S vssd1 vssd1 vccd1 vccd1 sky130_fd_sc_hd__diode_2
X_2774_ _4759_/Q _4774_/Q vssd1 vssd1 vccd1 vccd1 _2775_/D sky130_fd_sc_hd__nor2_1
X_4513_ _4624_/CLK _4513_/D fanout408/X vssd1 vssd1 vccd1 vccd1 _4513_/Q sky130_fd_sc_hd__dfrtp_1
XANTENNA__4552__RESET_B fanout423/X vssd1 vssd1 vccd1 vccd1 sky130_fd_sc_hd__diode_2
Xhold125 _4653_/Q vssd1 vssd1 vccd1 vccd1 hold125/X sky130_fd_sc_hd__dlygate4sd3_1
Xhold114 _4739_/Q vssd1 vssd1 vccd1 vccd1 hold114/X sky130_fd_sc_hd__dlygate4sd3_1
Xhold103 _4740_/Q vssd1 vssd1 vccd1 vccd1 hold103/X sky130_fd_sc_hd__dlygate4sd3_1
X_4444_ _4575_/CLK _4444_/D fanout437/X vssd1 vssd1 vccd1 vccd1 hold63/A sky130_fd_sc_hd__dfrtp_1
Xhold158 _4584_/Q vssd1 vssd1 vccd1 vccd1 hold158/X sky130_fd_sc_hd__dlygate4sd3_1
Xhold147 _4689_/Q vssd1 vssd1 vccd1 vccd1 hold147/X sky130_fd_sc_hd__dlygate4sd3_1
Xclkbuf_leaf_7_clk clkload1/A vssd1 vssd1 vccd1 vccd1 _4776_/CLK sky130_fd_sc_hd__clkbuf_8
Xhold136 _4747_/Q vssd1 vssd1 vccd1 vccd1 hold136/X sky130_fd_sc_hd__dlygate4sd3_1
X_4375_ _4371_/X _4372_/Y _4374_/X _4377_/C1 _4377_/B1 vssd1 vssd1 vccd1 vccd1 _4375_/X
+ sky130_fd_sc_hd__o311a_1
Xhold169 _4457_/Q vssd1 vssd1 vccd1 vccd1 hold169/X sky130_fd_sc_hd__dlygate4sd3_1
XANTENNA__3543__A _3543_/A vssd1 vssd1 vccd1 vccd1 sky130_fd_sc_hd__diode_2
XTAP_TAPCELL_ROW_69_812 vssd1 vccd1 sky130_fd_sc_hd__tapvpwrvgnd_1
X_3326_ _3333_/B _3324_/X _3528_/B _3323_/B vssd1 vssd1 vccd1 vccd1 _3333_/C sky130_fd_sc_hd__a22oi_1
XFILLER_85_113 vccd1 vssd1 vccd1 vssd1 sky130_ef_sc_hd__decap_12
XFILLER_85_146 vssd1 vssd1 vccd1 vccd1 sky130_fd_sc_hd__fill_1
XANTENNA_fanout284_A _4009_/A_N vssd1 vssd1 vccd1 vccd1 sky130_fd_sc_hd__diode_2
X_3257_ _4546_/Q _4587_/Q vssd1 vssd1 vccd1 vccd1 _3359_/C sky130_fd_sc_hd__or2_2
X_2208_ _4770_/Q vssd1 vssd1 vccd1 vccd1 _3142_/B sky130_fd_sc_hd__inv_2
X_3188_ _3188_/A _3188_/B vssd1 vssd1 vccd1 vccd1 _3191_/C sky130_fd_sc_hd__nor2_1
XFILLER_26_213 vssd1 vssd1 vccd1 vccd1 sky130_fd_sc_hd__fill_1
XTAP_TAPCELL_ROW_24_403 vssd1 vccd1 sky130_fd_sc_hd__tapvpwrvgnd_1
XANTENNA_fanout337_X _4328_/A vssd1 vssd1 vccd1 vccd1 sky130_fd_sc_hd__diode_2
XANTENNA__3966__A2 _3873_/Y vssd1 vssd1 vccd1 vccd1 sky130_fd_sc_hd__diode_2
XTAP_TAPCELL_ROW_32_480 vssd1 vccd1 sky130_fd_sc_hd__tapvpwrvgnd_1
XANTENNA__4313__S _4313_/S vssd1 vssd1 vccd1 vccd1 sky130_fd_sc_hd__diode_2
XFILLER_5_117 vssd1 vssd1 vccd1 vccd1 sky130_fd_sc_hd__fill_1
XFILLER_1_334 vssd1 vssd1 vccd1 vccd1 sky130_fd_sc_hd__fill_2
XFILLER_1_345 vccd1 vssd1 vccd1 vssd1 sky130_ef_sc_hd__decap_12
XFILLER_1_389 vssd1 vssd1 vccd1 vccd1 sky130_fd_sc_hd__decap_3
XFILLER_49_349 vssd1 vssd1 vccd1 vccd1 sky130_fd_sc_hd__decap_4
XANTENNA_input12_A s_axis_tdata[18] vssd1 vssd1 vccd1 vccd1 sky130_fd_sc_hd__diode_2
XFILLER_17_213 vssd1 vssd1 vccd1 vccd1 sky130_fd_sc_hd__decap_8
XFILLER_17_246 vssd1 vssd1 vccd1 vccd1 sky130_fd_sc_hd__decap_4
XFILLER_57_393 vccd1 vssd1 vccd1 vssd1 sky130_ef_sc_hd__decap_12
X_2490_ _3809_/A _3809_/B _4666_/Q _3943_/A2 vssd1 vssd1 vccd1 vccd1 _2490_/X sky130_fd_sc_hd__o211a_1
X_4160_ _4223_/D _4172_/B _4168_/C _4227_/C vssd1 vssd1 vccd1 vccd1 _4160_/X sky130_fd_sc_hd__and4b_1
X_3111_ _3044_/Y _2919_/X _3108_/Y _3107_/X _3087_/C vssd1 vssd1 vccd1 vccd1 _3111_/Y
+ sky130_fd_sc_hd__o221ai_4
X_4091_ _4103_/A0 _4103_/A1 _4231_/C vssd1 vssd1 vccd1 vccd1 _4091_/X sky130_fd_sc_hd__mux2_1
X_3042_ _3029_/Y _3041_/Y _3157_/A2 vssd1 vssd1 vccd1 vccd1 _3042_/Y sky130_fd_sc_hd__o21ai_1
XTAP_TAPCELL_ROW_38_528 vssd1 vccd1 sky130_fd_sc_hd__tapvpwrvgnd_1
XFILLER_82_138 vssd1 vssd1 vccd1 vccd1 sky130_fd_sc_hd__fill_2
XFILLER_51_514 vssd1 vssd1 vccd1 vccd1 sky130_fd_sc_hd__fill_1
XFILLER_63_385 vssd1 vssd1 vccd1 vccd1 sky130_fd_sc_hd__decap_6
XANTENNA__3948__A2 _3873_/Y vssd1 vssd1 vccd1 vccd1 sky130_fd_sc_hd__diode_2
X_3944_ _3872_/X _3971_/A1 _4005_/D vssd1 vssd1 vccd1 vccd1 _3944_/X sky130_fd_sc_hd__mux2_1
X_3875_ _3875_/A0 hold159/X _3928_/S vssd1 vssd1 vccd1 vccd1 _4651_/D sky130_fd_sc_hd__mux2_1
XFILLER_31_271 vssd1 vssd1 vccd1 vccd1 sky130_fd_sc_hd__fill_2
X_2826_ _4758_/Q _4773_/Q _2786_/C _2788_/Y _2823_/Y vssd1 vssd1 vccd1 vccd1 _2827_/B
+ sky130_fd_sc_hd__a311oi_1
X_2757_ _2754_/X _2755_/Y _2717_/B _2717_/Y vssd1 vssd1 vccd1 vccd1 _2758_/C sky130_fd_sc_hd__o211ai_1
X_2688_ _2688_/A _2688_/B _2688_/C vssd1 vssd1 vccd1 vccd1 _2689_/B sky130_fd_sc_hd__and3_1
XANTENNA__4125__A2 _4173_/A2 vssd1 vssd1 vccd1 vccd1 sky130_fd_sc_hd__diode_2
X_4427_ _4668_/CLK _4427_/D fanout423/X vssd1 vssd1 vccd1 vccd1 hold28/A sky130_fd_sc_hd__dfrtp_1
Xfanout402 fanout404/X vssd1 vssd1 vccd1 vccd1 fanout402/X sky130_fd_sc_hd__clkbuf_4
Xfanout413 fanout414/X vssd1 vssd1 vccd1 vccd1 fanout413/X sky130_fd_sc_hd__buf_2
XFILLER_48_16 vssd1 vssd1 vccd1 vccd1 sky130_fd_sc_hd__fill_1
XANTENNA_input4_A s_axis_tdata[10] vssd1 vssd1 vccd1 vccd1 sky130_fd_sc_hd__diode_2
X_4358_ _4782_/Q _4358_/A2 _4355_/X _4357_/X vssd1 vssd1 vccd1 vccd1 _4782_/D sky130_fd_sc_hd__o22a_1
Xfanout424 input2/X vssd1 vssd1 vccd1 vccd1 fanout424/X sky130_fd_sc_hd__clkbuf_2
XANTENNA__3884__A1 _4136_/B vssd1 vssd1 vccd1 vccd1 sky130_fd_sc_hd__diode_2
Xfanout435 fanout440/X vssd1 vssd1 vccd1 vccd1 fanout435/X sky130_fd_sc_hd__buf_2
XFILLER_48_27 vssd1 vssd1 vccd1 vccd1 sky130_fd_sc_hd__fill_1
XANTENNA__4088__B _4104_/B vssd1 vssd1 vccd1 vccd1 sky130_fd_sc_hd__diode_2
X_3309_ _3307_/X _3309_/B vssd1 vssd1 vccd1 vccd1 _3516_/A sky130_fd_sc_hd__and2b_1
X_4289_ _4305_/A0 _4305_/A1 _4360_/A vssd1 vssd1 vccd1 vccd1 _4289_/X sky130_fd_sc_hd__mux2_1
XANTENNA_fanout287_X _4104_/C vssd1 vssd1 vccd1 vccd1 sky130_fd_sc_hd__diode_2
XFILLER_86_477 vccd1 vssd1 vccd1 vssd1 sky130_ef_sc_hd__decap_12
XFILLER_64_26 vssd1 vssd1 vccd1 vccd1 sky130_fd_sc_hd__fill_2
XFILLER_64_59 vccd1 vssd1 vccd1 vssd1 sky130_ef_sc_hd__decap_12
XTAP_TAPCELL_ROW_1_197 vssd1 vccd1 sky130_fd_sc_hd__tapvpwrvgnd_1
XANTENNA__4254__D _4320_/A vssd1 vssd1 vccd1 vccd1 sky130_fd_sc_hd__diode_2
XFILLER_81_193 vssd1 vssd1 vccd1 vccd1 sky130_fd_sc_hd__fill_1
XANTENNA__4061__A1 _4123_/S vssd1 vssd1 vccd1 vccd1 sky130_fd_sc_hd__diode_2
XFILLER_10_411 vssd1 vssd1 vccd1 vccd1 sky130_fd_sc_hd__fill_1
Xfanout86 _3460_/B1 vssd1 vssd1 vccd1 vccd1 _3536_/B1 sky130_fd_sc_hd__buf_2
XFILLER_22_282 vssd1 vssd1 vccd1 vccd1 sky130_fd_sc_hd__fill_2
Xfanout97 _3735_/S vssd1 vssd1 vccd1 vccd1 _3655_/S sky130_fd_sc_hd__buf_2
XFILLER_10_477 vccd1 vssd1 vccd1 vssd1 sky130_ef_sc_hd__decap_12
XFILLER_49_113 vssd1 vssd1 vccd1 vccd1 sky130_fd_sc_hd__fill_2
XANTENNA__4218__S _4223_/C vssd1 vssd1 vccd1 vccd1 sky130_fd_sc_hd__diode_2
XFILLER_45_341 vssd1 vssd1 vccd1 vccd1 sky130_fd_sc_hd__fill_1
XANTENNA__4164__D _4231_/C vssd1 vssd1 vccd1 vccd1 sky130_fd_sc_hd__diode_2
XFILLER_60_355 vssd1 vssd1 vccd1 vccd1 sky130_fd_sc_hd__decap_6
XFILLER_13_260 vssd1 vssd1 vccd1 vccd1 sky130_fd_sc_hd__fill_2
XTAP_TAPCELL_ROW_43_575 vssd1 vccd1 sky130_fd_sc_hd__tapvpwrvgnd_1
X_3660_ _3630_/Y _3657_/B _3661_/B vssd1 vssd1 vccd1 vccd1 _3660_/Y sky130_fd_sc_hd__a21boi_1
Xclkload23 _4818_/CLK vssd1 vssd1 vccd1 vccd1 clkload23/Y sky130_fd_sc_hd__inv_6
Xclkload34 _4669_/CLK vssd1 vssd1 vccd1 vccd1 clkload34/X sky130_fd_sc_hd__clkbuf_4
Xclkload12 _4806_/CLK vssd1 vssd1 vccd1 vccd1 clkload12/Y sky130_fd_sc_hd__clkinvlp_4
X_3591_ _3588_/Y _3587_/Y _3655_/S vssd1 vssd1 vccd1 vccd1 _3591_/X sky130_fd_sc_hd__a21o_1
X_2611_ _2612_/A _2612_/B vssd1 vssd1 vccd1 vccd1 _2613_/A sky130_fd_sc_hd__nand2_1
Xclkload45 _4576_/CLK vssd1 vssd1 vccd1 vccd1 clkload45/Y sky130_fd_sc_hd__inv_8
X_2542_ _2588_/B _2542_/B vssd1 vssd1 vccd1 vccd1 _2552_/A sky130_fd_sc_hd__nand2_1
XFILLER_55_3 vssd1 vssd1 vccd1 vccd1 sky130_fd_sc_hd__decap_4
XPHY_EDGE_ROW_81_Left_169 vssd1 vssd1 vccd1 vccd1 sky130_fd_sc_hd__decap_3
X_2473_ _2473_/A _2473_/B vssd1 vssd1 vccd1 vccd1 _2474_/B sky130_fd_sc_hd__nand2_1
X_4212_ _4273_/S _4212_/A2 _4224_/B1 vssd1 vssd1 vccd1 vccd1 _4212_/Y sky130_fd_sc_hd__o21ai_1
XFILLER_68_400 vssd1 vssd1 vccd1 vccd1 sky130_fd_sc_hd__decap_8
X_4143_ _4171_/A0 _4167_/A1 _4215_/C vssd1 vssd1 vccd1 vccd1 _4143_/X sky130_fd_sc_hd__mux2_1
XFILLER_68_477 vssd1 vssd1 vccd1 vccd1 sky130_fd_sc_hd__fill_2
X_4074_ _4073_/Y _4072_/X _4071_/X hold98/X _4192_/B1 vssd1 vssd1 vccd1 vccd1 _4710_/D
+ sky130_fd_sc_hd__o32a_1
X_3025_ _3025_/A _3025_/B vssd1 vssd1 vccd1 vccd1 _3026_/B sky130_fd_sc_hd__xor2_2
XFILLER_51_377 vssd1 vssd1 vccd1 vccd1 sky130_fd_sc_hd__decap_4
X_3927_ _3872_/X _3971_/A1 _3981_/D vssd1 vssd1 vccd1 vccd1 _3927_/X sky130_fd_sc_hd__mux2_1
X_3858_ _3862_/A _3863_/A2 _3144_/B _3145_/B _3145_/A vssd1 vssd1 vccd1 vccd1 _3867_/A
+ sky130_fd_sc_hd__a32oi_1
XANTENNA_fanout414_A fanout424/X vssd1 vssd1 vccd1 vccd1 sky130_fd_sc_hd__diode_2
Xclkload6 clkload6/A vssd1 vssd1 vccd1 vccd1 clkload6/Y sky130_fd_sc_hd__clkinv_2
X_3789_ _3785_/Y _3786_/X _3778_/Y _3781_/Y vssd1 vssd1 vccd1 vccd1 _3791_/A sky130_fd_sc_hd__o211ai_1
X_2809_ hold95/A hold93/A vssd1 vssd1 vccd1 vccd1 _2810_/B sky130_fd_sc_hd__nor2_1
XANTENNA_fanout202_X _2323_/B vssd1 vssd1 vccd1 vccd1 sky130_fd_sc_hd__diode_2
Xfanout232 _4328_/B vssd1 vssd1 vccd1 vccd1 _4371_/B sky130_fd_sc_hd__clkbuf_2
Xfanout221 _3926_/X vssd1 vssd1 vccd1 vccd1 _3974_/A1 sky130_fd_sc_hd__clkbuf_2
Xfanout210 _2228_/Y vssd1 vssd1 vccd1 vccd1 _2274_/A sky130_fd_sc_hd__clkbuf_2
XFILLER_86_241 vssd1 vssd1 vccd1 vccd1 sky130_fd_sc_hd__decap_8
Xfanout254 _4278_/A_N vssd1 vssd1 vccd1 vccd1 _4245_/D sky130_fd_sc_hd__clkbuf_2
Xfanout265 _4211_/B vssd1 vssd1 vccd1 vccd1 _4239_/B sky130_fd_sc_hd__clkbuf_2
XTAP_TAPCELL_ROW_6_245 vssd1 vccd1 sky130_fd_sc_hd__tapvpwrvgnd_1
Xfanout243 fanout248/X vssd1 vssd1 vccd1 vccd1 _2381_/S sky130_fd_sc_hd__clkbuf_2
Xfanout298 _4372_/A vssd1 vssd1 vccd1 vccd1 _4371_/A sky130_fd_sc_hd__buf_2
Xfanout276 _4132_/C vssd1 vssd1 vccd1 vccd1 _4120_/C sky130_fd_sc_hd__clkbuf_2
Xfanout287 _4009_/A_N vssd1 vssd1 vccd1 vccd1 _4104_/C sky130_fd_sc_hd__buf_2
XTAP_TAPCELL_ROW_85_954 vssd1 vccd1 sky130_fd_sc_hd__tapvpwrvgnd_1
XFILLER_74_436 vssd1 vssd1 vccd1 vccd1 sky130_fd_sc_hd__fill_2
XFILLER_15_503 vssd1 vssd1 vccd1 vccd1 sky130_fd_sc_hd__fill_1
XFILLER_61_108 vssd1 vssd1 vccd1 vccd1 sky130_fd_sc_hd__fill_1
XFILLER_27_385 vssd1 vssd1 vccd1 vccd1 sky130_fd_sc_hd__decap_6
XANTENNA__3793__B1 _3549_/A vssd1 vssd1 vccd1 vccd1 sky130_fd_sc_hd__diode_2
XTAP_TAPCELL_ROW_40_545 vssd1 vccd1 sky130_fd_sc_hd__tapvpwrvgnd_1
XANTENNA__4337__A2 _4328_/C vssd1 vssd1 vccd1 vccd1 sky130_fd_sc_hd__diode_2
XANTENNA__3545__B1 _3613_/B vssd1 vssd1 vccd1 vccd1 sky130_fd_sc_hd__diode_2
XFILLER_40_83 vssd1 vssd1 vccd1 vccd1 sky130_fd_sc_hd__fill_1
XTAP_TAPCELL_ROW_48_623 vssd1 vccd1 sky130_fd_sc_hd__tapvpwrvgnd_1
XFILLER_1_77 vssd1 vssd1 vccd1 vccd1 sky130_fd_sc_hd__decap_4
XFILLER_60_141 vssd1 vssd1 vccd1 vccd1 sky130_fd_sc_hd__fill_1
XFILLER_60_163 vssd1 vssd1 vccd1 vccd1 sky130_fd_sc_hd__fill_1
XANTENNA__4191__B _4211_/B vssd1 vssd1 vccd1 vccd1 sky130_fd_sc_hd__diode_2
X_4761_ _4776_/CLK _4761_/D fanout399/X vssd1 vssd1 vccd1 vccd1 _4761_/Q sky130_fd_sc_hd__dfrtp_1
X_4692_ clkload4/A _4692_/D fanout378/X vssd1 vssd1 vccd1 vccd1 _4692_/Q sky130_fd_sc_hd__dfrtp_1
X_3712_ _3707_/Y _3710_/X _3543_/B _3923_/A vssd1 vssd1 vccd1 vccd1 _3712_/X sky130_fd_sc_hd__o211a_1
X_3643_ _3643_/A _3643_/B _3643_/C vssd1 vssd1 vccd1 vccd1 _3656_/A sky130_fd_sc_hd__nor3_1
XTAP_TAPCELL_ROW_11_291 vssd1 vccd1 sky130_fd_sc_hd__tapvpwrvgnd_1
XANTENNA__2339__A1 _4037_/D vssd1 vssd1 vccd1 vccd1 sky130_fd_sc_hd__diode_2
XANTENNA__4411__S _4411_/S vssd1 vssd1 vccd1 vccd1 sky130_fd_sc_hd__diode_2
X_3574_ _3564_/X _3567_/X _3571_/Y _3572_/Y vssd1 vssd1 vccd1 vccd1 _3574_/Y sky130_fd_sc_hd__o211ai_1
X_2525_ _2497_/A _2497_/B _2500_/Y vssd1 vssd1 vccd1 vccd1 _2530_/B sky130_fd_sc_hd__o21ai_1
X_2456_ _2470_/C _2456_/B _4455_/Q vssd1 vssd1 vccd1 vccd1 _2456_/Y sky130_fd_sc_hd__nor3b_1
Xhold18 hold18/A vssd1 vssd1 vccd1 vccd1 hold18/X sky130_fd_sc_hd__dlygate4sd3_1
Xhold29 hold29/A vssd1 vssd1 vccd1 vccd1 hold29/X sky130_fd_sc_hd__dlygate4sd3_1
XTAP_TAPCELL_ROW_3_215 vssd1 vccd1 sky130_fd_sc_hd__tapvpwrvgnd_1
X_4126_ _4123_/X _4124_/X _4125_/Y _4130_/B1 hold79/X vssd1 vssd1 vccd1 vccd1 _4723_/D
+ sky130_fd_sc_hd__o32a_1
X_2387_ _4561_/Q hold72/A _2425_/S vssd1 vssd1 vccd1 vccd1 _2387_/X sky130_fd_sc_hd__mux2_1
XFILLER_56_414 vssd1 vssd1 vccd1 vccd1 sky130_fd_sc_hd__decap_6
XFILLER_68_285 vssd1 vssd1 vccd1 vccd1 sky130_fd_sc_hd__fill_1
XFILLER_83_255 vssd1 vssd1 vccd1 vccd1 sky130_fd_sc_hd__decap_6
X_4057_ _4119_/S _4081_/A2 _4058_/B2 vssd1 vssd1 vccd1 vccd1 _4057_/Y sky130_fd_sc_hd__o21ai_1
XTAP_TAPCELL_ROW_82_924 vssd1 vccd1 sky130_fd_sc_hd__tapvpwrvgnd_1
X_3008_ _3008_/A _3008_/B vssd1 vssd1 vccd1 vccd1 _3009_/B sky130_fd_sc_hd__nor2_1
XFILLER_10_64 vssd1 vssd1 vccd1 vccd1 sky130_fd_sc_hd__fill_1
XFILLER_10_42 vssd1 vssd1 vccd1 vccd1 sky130_fd_sc_hd__fill_1
XFILLER_3_259 vssd1 vssd1 vccd1 vccd1 sky130_fd_sc_hd__fill_1
XFILLER_74_222 vccd1 vssd1 vccd1 vssd1 sky130_ef_sc_hd__decap_12
XFILLER_47_447 vssd1 vssd1 vccd1 vccd1 sky130_fd_sc_hd__fill_1
XANTENNA__4255__A1 _4320_/A vssd1 vssd1 vccd1 vccd1 sky130_fd_sc_hd__diode_2
XTAP_TAPCELL_ROW_17_339 vssd1 vccd1 sky130_fd_sc_hd__tapvpwrvgnd_1
XTAP_TAPCELL_ROW_53_670 vssd1 vccd1 sky130_fd_sc_hd__tapvpwrvgnd_1
XANTENNA__2811__Y _2812_/C vssd1 vssd1 vccd1 vccd1 sky130_fd_sc_hd__diode_2
X_2310_ _2341_/A0 _2310_/A1 _4075_/S vssd1 vssd1 vccd1 vccd1 _2310_/X sky130_fd_sc_hd__mux2_1
X_3290_ _4558_/Q _4599_/Q vssd1 vssd1 vccd1 vccd1 _3427_/A sky130_fd_sc_hd__xor2_1
X_2241_ hold31/X _4549_/Q _2242_/S vssd1 vssd1 vccd1 vccd1 _4420_/D sky130_fd_sc_hd__mux2_1
XFILLER_65_222 vssd1 vssd1 vccd1 vccd1 sky130_fd_sc_hd__fill_2
XFILLER_18_3 vssd1 vssd1 vccd1 vccd1 sky130_fd_sc_hd__fill_1
XFILLER_80_214 vssd1 vssd1 vccd1 vccd1 sky130_fd_sc_hd__fill_2
XFILLER_65_299 vccd1 vssd1 vccd1 vssd1 sky130_ef_sc_hd__decap_12
XFILLER_80_236 vccd1 vssd1 vccd1 vssd1 sky130_ef_sc_hd__decap_12
X_4813_ _4815_/CLK _4813_/D fanout394/X vssd1 vssd1 vccd1 vccd1 _4813_/Q sky130_fd_sc_hd__dfrtp_1
XFILLER_33_174 vccd1 vssd1 vccd1 vssd1 sky130_ef_sc_hd__decap_12
XANTENNA__3757__B1 _3549_/A vssd1 vssd1 vccd1 vccd1 sky130_fd_sc_hd__diode_2
X_4744_ _4744_/CLK _4744_/D fanout389/X vssd1 vssd1 vccd1 vccd1 _4744_/Q sky130_fd_sc_hd__dfrtp_1
X_4675_ _4806_/CLK _4675_/D fanout385/X vssd1 vssd1 vccd1 vccd1 _4675_/Q sky130_fd_sc_hd__dfrtp_1
X_3626_ _4518_/Q _4627_/Q _3625_/X vssd1 vssd1 vccd1 vccd1 _3627_/C sky130_fd_sc_hd__a21o_1
XANTENNA_fanout112_A _2428_/Y vssd1 vssd1 vccd1 vccd1 sky130_fd_sc_hd__diode_2
X_3557_ hold158/X _3603_/S _3556_/X vssd1 vssd1 vccd1 vccd1 _4584_/D sky130_fd_sc_hd__a21o_1
XANTENNA__4182__A0 _4214_/A0 vssd1 vssd1 vccd1 vccd1 sky130_fd_sc_hd__diode_2
X_2508_ _3811_/A _3811_/B _4666_/Q _3946_/A2 vssd1 vssd1 vccd1 vccd1 _2508_/X sky130_fd_sc_hd__o211a_1
X_3488_ _3536_/A2 _3486_/X _3491_/C _3536_/B1 vssd1 vssd1 vccd1 vccd1 _3488_/X sky130_fd_sc_hd__a31o_1
X_2439_ _4659_/Q _2439_/B vssd1 vssd1 vccd1 vccd1 _2439_/Y sky130_fd_sc_hd__xnor2_1
XTAP_TAPCELL_ROW_59_718 vssd1 vccd1 sky130_fd_sc_hd__tapvpwrvgnd_1
XANTENNA__4096__B _4104_/B vssd1 vssd1 vccd1 vccd1 sky130_fd_sc_hd__diode_2
XFILLER_56_200 vssd1 vssd1 vccd1 vccd1 sky130_fd_sc_hd__fill_1
XFILLER_56_211 vssd1 vssd1 vccd1 vccd1 sky130_fd_sc_hd__fill_1
X_4109_ _3023_/A _4361_/B1 _4108_/Y _4107_/X vssd1 vssd1 vccd1 vccd1 _4719_/D sky130_fd_sc_hd__a22o_1
XTAP_TAPCELL_ROW_67_795 vssd1 vccd1 sky130_fd_sc_hd__tapvpwrvgnd_1
XANTENNA__3996__A0 _4020_/A0 vssd1 vssd1 vccd1 vccd1 sky130_fd_sc_hd__diode_2
XFILLER_24_141 vssd1 vssd1 vccd1 vccd1 sky130_fd_sc_hd__fill_1
XFILLER_52_461 vccd1 vssd1 vccd1 vssd1 sky130_ef_sc_hd__decap_12
XTAP_TAPCELL_ROW_50_640 vssd1 vccd1 sky130_fd_sc_hd__tapvpwrvgnd_1
XANTENNA__4262__D _4323_/S vssd1 vssd1 vccd1 vccd1 sky130_fd_sc_hd__diode_2
XTAP_TAPCELL_ROW_22_386 vssd1 vccd1 sky130_fd_sc_hd__tapvpwrvgnd_1
XFILLER_4_513 vssd1 vssd1 vccd1 vccd1 sky130_fd_sc_hd__decap_6
XANTENNA__4051__S _4119_/S vssd1 vssd1 vccd1 vccd1 sky130_fd_sc_hd__diode_2
XANTENNA__3890__S _3890_/S vssd1 vssd1 vccd1 vccd1 sky130_fd_sc_hd__diode_2
XFILLER_87_391 vssd1 vssd1 vccd1 vccd1 sky130_fd_sc_hd__fill_1
XFILLER_47_244 vssd1 vssd1 vccd1 vccd1 sky130_fd_sc_hd__fill_1
XANTENNA__4228__A1 _4227_/C vssd1 vssd1 vccd1 vccd1 sky130_fd_sc_hd__diode_2
XPHY_EDGE_ROW_6_Left_94 vssd1 vssd1 vccd1 vccd1 sky130_fd_sc_hd__decap_3
XANTENNA__4226__S _4231_/C vssd1 vssd1 vccd1 vccd1 sky130_fd_sc_hd__diode_2
XFILLER_15_141 vccd1 vssd1 vccd1 vssd1 sky130_ef_sc_hd__decap_12
XFILLER_43_461 vssd1 vssd1 vccd1 vccd1 sky130_fd_sc_hd__fill_2
XANTENNA__4172__D _4372_/A vssd1 vssd1 vccd1 vccd1 sky130_fd_sc_hd__diode_2
X_2790_ _2790_/A _2790_/B vssd1 vssd1 vccd1 vccd1 _2793_/A sky130_fd_sc_hd__nand2_1
XFILLER_11_391 vssd1 vssd1 vccd1 vccd1 sky130_fd_sc_hd__fill_1
X_4460_ clkload5/A _4460_/D fanout377/X vssd1 vssd1 vccd1 vccd1 _4460_/Q sky130_fd_sc_hd__dfrtp_1
X_4391_ _4231_/C input6/X _4406_/S vssd1 vssd1 vccd1 vccd1 _4800_/D sky130_fd_sc_hd__mux2_1
X_3411_ _3233_/Y _3405_/Y _3225_/X vssd1 vssd1 vccd1 vccd1 _3412_/A sky130_fd_sc_hd__a21oi_1
X_3342_ _4542_/Q _3396_/A2 _3340_/X _3341_/X vssd1 vssd1 vccd1 vccd1 _4542_/D sky130_fd_sc_hd__a22o_1
XFILLER_85_317 vssd1 vssd1 vccd1 vccd1 sky130_fd_sc_hd__decap_4
X_3273_ _3273_/A _3273_/B _3359_/C vssd1 vssd1 vccd1 vccd1 _3370_/B sky130_fd_sc_hd__nand3_2
X_2224_ _4819_/Q vssd1 vssd1 vccd1 vccd1 _2224_/Y sky130_fd_sc_hd__inv_2
XFILLER_38_200 vssd1 vssd1 vccd1 vccd1 sky130_fd_sc_hd__decap_8
XFILLER_81_501 vssd1 vssd1 vccd1 vccd1 sky130_fd_sc_hd__decap_3
XFILLER_38_288 vccd1 vssd1 vccd1 vssd1 sky130_ef_sc_hd__decap_12
XTAP_TAPCELL_ROW_64_765 vssd1 vccd1 sky130_fd_sc_hd__tapvpwrvgnd_1
XFILLER_41_409 vssd1 vssd1 vccd1 vccd1 sky130_fd_sc_hd__fill_2
XFILLER_21_111 vssd1 vssd1 vccd1 vccd1 sky130_fd_sc_hd__fill_1
XANTENNA__3975__S _3975_/S vssd1 vssd1 vccd1 vccd1 sky130_fd_sc_hd__diode_2
X_2988_ _3033_/B _2988_/B _3074_/C vssd1 vssd1 vccd1 vccd1 _2988_/Y sky130_fd_sc_hd__nor3_1
XANTENNA_fanout327_A _2304_/A1 vssd1 vssd1 vccd1 vccd1 sky130_fd_sc_hd__diode_2
X_4727_ _4744_/CLK _4727_/D fanout380/X vssd1 vssd1 vccd1 vccd1 _4727_/Q sky130_fd_sc_hd__dfrtp_1
X_4658_ _4669_/CLK _4658_/D fanout407/X vssd1 vssd1 vccd1 vccd1 _4658_/Q sky130_fd_sc_hd__dfrtp_1
X_3609_ _3587_/A _3590_/Y _3608_/X vssd1 vssd1 vccd1 vccd1 _3609_/Y sky130_fd_sc_hd__o21bai_2
XANTENNA__4155__A0 _4171_/A0 vssd1 vssd1 vccd1 vccd1 sky130_fd_sc_hd__diode_2
XFILLER_1_505 vccd1 vssd1 vccd1 vssd1 sky130_ef_sc_hd__decap_12
X_4589_ _4624_/CLK _4589_/D fanout409/X vssd1 vssd1 vccd1 vccd1 _4589_/Q sky130_fd_sc_hd__dfrtp_4
XTAP_TAPCELL_ROW_27_434 vssd1 vccd1 sky130_fd_sc_hd__tapvpwrvgnd_1
XFILLER_16_41 vccd1 vssd1 vccd1 vssd1 sky130_ef_sc_hd__decap_12
XPHY_EDGE_ROW_11_Right_11 vssd1 vssd1 vccd1 vccd1 sky130_fd_sc_hd__decap_3
XANTENNA__2802__B _4468_/Q vssd1 vssd1 vccd1 vccd1 sky130_fd_sc_hd__diode_2
XFILLER_4_365 vccd1 vssd1 vccd1 vssd1 sky130_ef_sc_hd__decap_12
XPHY_EDGE_ROW_20_Right_20 vssd1 vssd1 vccd1 vccd1 sky130_fd_sc_hd__decap_3
XFILLER_35_225 vssd1 vssd1 vccd1 vccd1 sky130_fd_sc_hd__fill_2
X_3960_ _4087_/S _3873_/Y _3959_/X _4015_/B2 vssd1 vssd1 vccd1 vccd1 _3960_/X sky130_fd_sc_hd__o211a_1
XFILLER_73_91 vssd1 vssd1 vccd1 vccd1 sky130_fd_sc_hd__decap_6
X_2911_ _2911_/A _2911_/B _2911_/C vssd1 vssd1 vccd1 vccd1 _2913_/A sky130_fd_sc_hd__or3_2
XFILLER_16_461 vccd1 vssd1 vccd1 vssd1 sky130_ef_sc_hd__decap_12
XANTENNA__4183__C _4199_/D vssd1 vssd1 vccd1 vccd1 sky130_fd_sc_hd__diode_2
XFILLER_50_217 vssd1 vssd1 vccd1 vccd1 sky130_fd_sc_hd__decap_8
XFILLER_50_239 vccd1 vssd1 vccd1 vssd1 sky130_ef_sc_hd__decap_12
XTAP_TAPCELL_ROW_61_735 vssd1 vccd1 sky130_fd_sc_hd__tapvpwrvgnd_1
X_3891_ _4816_/Q _4306_/C vssd1 vssd1 vccd1 vccd1 _4246_/B sky130_fd_sc_hd__or2_1
XFILLER_85_3 vccd1 vssd1 vccd1 vssd1 sky130_ef_sc_hd__decap_12
XANTENNA__4385__A0 _4005_/D vssd1 vssd1 vccd1 vccd1 sky130_fd_sc_hd__diode_2
XFILLER_31_475 vssd1 vssd1 vccd1 vccd1 sky130_fd_sc_hd__fill_1
X_2842_ _2842_/A _2842_/B vssd1 vssd1 vccd1 vccd1 _2848_/A sky130_fd_sc_hd__nor2_1
X_2773_ _4759_/Q _4774_/Q vssd1 vssd1 vccd1 vccd1 _2775_/C sky130_fd_sc_hd__and2_1
X_4512_ _4669_/CLK _4512_/D fanout406/X vssd1 vssd1 vccd1 vccd1 _4512_/Q sky130_fd_sc_hd__dfrtp_4
Xhold115 _4735_/Q vssd1 vssd1 vccd1 vccd1 hold115/X sky130_fd_sc_hd__dlygate4sd3_1
Xhold126 _4734_/Q vssd1 vssd1 vccd1 vccd1 hold126/X sky130_fd_sc_hd__dlygate4sd3_1
Xhold104 _4717_/Q vssd1 vssd1 vccd1 vccd1 hold104/X sky130_fd_sc_hd__dlygate4sd3_1
X_4443_ _4575_/CLK _4443_/D fanout436/X vssd1 vssd1 vccd1 vccd1 hold77/A sky130_fd_sc_hd__dfrtp_1
Xhold159 _4651_/Q vssd1 vssd1 vccd1 vccd1 hold159/X sky130_fd_sc_hd__dlygate4sd3_1
Xhold137 _4655_/Q vssd1 vssd1 vccd1 vccd1 hold137/X sky130_fd_sc_hd__dlygate4sd3_1
Xhold148 _4663_/Q vssd1 vssd1 vccd1 vccd1 hold148/X sky130_fd_sc_hd__dlygate4sd3_1
X_4374_ _4374_/A0 _4374_/A1 _4374_/S vssd1 vssd1 vccd1 vccd1 _4374_/X sky130_fd_sc_hd__mux2_1
X_3325_ _4577_/Q _4578_/Q _3318_/B vssd1 vssd1 vccd1 vccd1 _3535_/B sky130_fd_sc_hd__o21ai_1
XFILLER_85_125 vssd1 vssd1 vccd1 vccd1 sky130_fd_sc_hd__fill_1
XTAP_TAPCELL_ROW_69_813 vssd1 vccd1 sky130_fd_sc_hd__tapvpwrvgnd_1
X_3256_ _4547_/Q _4588_/Q vssd1 vssd1 vccd1 vccd1 _3273_/B sky130_fd_sc_hd__xor2_2
X_2207_ _4736_/Q vssd1 vssd1 vccd1 vccd1 _3025_/A sky130_fd_sc_hd__clkinv_4
X_3187_ _3187_/A _3498_/B _3187_/C _3487_/B vssd1 vssd1 vccd1 vccd1 _3188_/A sky130_fd_sc_hd__nand4_1
XANTENNA_fanout277_A _4811_/Q vssd1 vssd1 vccd1 vccd1 sky130_fd_sc_hd__diode_2
XTAP_TAPCELL_ROW_24_404 vssd1 vccd1 sky130_fd_sc_hd__tapvpwrvgnd_1
XANTENNA__3415__A2 _3425_/A2 vssd1 vssd1 vccd1 vccd1 sky130_fd_sc_hd__diode_2
XFILLER_22_453 vccd1 vssd1 vccd1 vssd1 sky130_ef_sc_hd__decap_12
XTAP_TAPCELL_ROW_32_481 vssd1 vccd1 sky130_fd_sc_hd__tapvpwrvgnd_1
XANTENNA_fanout92_A _4410_/S vssd1 vssd1 vccd1 vccd1 sky130_fd_sc_hd__diode_2
XFILLER_78_69 vccd1 vssd1 vccd1 vssd1 sky130_ef_sc_hd__decap_12
XFILLER_1_357 vccd1 vssd1 vccd1 vssd1 sky130_ef_sc_hd__decap_12
XFILLER_57_350 vccd1 vssd1 vccd1 vssd1 sky130_ef_sc_hd__decap_12
XFILLER_17_225 vssd1 vssd1 vccd1 vccd1 sky130_fd_sc_hd__decap_8
XFILLER_13_420 vccd1 vssd1 vccd1 vssd1 sky130_ef_sc_hd__decap_12
XFILLER_13_464 vssd1 vssd1 vccd1 vccd1 sky130_fd_sc_hd__fill_1
XFILLER_40_250 vssd1 vssd1 vccd1 vccd1 sky130_fd_sc_hd__fill_2
XFILLER_40_283 vccd1 vssd1 vccd1 vssd1 sky130_ef_sc_hd__decap_12
XANTENNA__4801__Q _4801_/Q vssd1 vssd1 vccd1 vccd1 sky130_fd_sc_hd__diode_2
XANTENNA__4119__A0 _4167_/A0 vssd1 vssd1 vccd1 vccd1 sky130_fd_sc_hd__diode_2
X_3110_ _3044_/Y _2919_/X _3108_/Y _3107_/X _3087_/C vssd1 vssd1 vccd1 vccd1 _3112_/B
+ sky130_fd_sc_hd__o221a_1
XFILLER_68_91 vssd1 vssd1 vccd1 vccd1 sky130_fd_sc_hd__fill_1
X_4090_ _4089_/Y _4088_/X _4087_/X hold132/X _4208_/B1 vssd1 vssd1 vccd1 vccd1 _4714_/D
+ sky130_fd_sc_hd__o32a_1
X_3041_ _3055_/B _3041_/B vssd1 vssd1 vccd1 vccd1 _3041_/Y sky130_fd_sc_hd__nand2_1
XTAP_TAPCELL_ROW_38_529 vssd1 vccd1 sky130_fd_sc_hd__tapvpwrvgnd_1
XFILLER_48_383 vccd1 vssd1 vccd1 vssd1 sky130_ef_sc_hd__decap_12
XFILLER_63_342 vssd1 vssd1 vccd1 vccd1 sky130_fd_sc_hd__decap_6
X_3943_ _3946_/A1 _3943_/A2 _3941_/X _3942_/X vssd1 vssd1 vccd1 vccd1 _4674_/D sky130_fd_sc_hd__a31o_1
X_3874_ _3872_/X hold96/X _3928_/S vssd1 vssd1 vccd1 vccd1 _4650_/D sky130_fd_sc_hd__mux2_1
X_2825_ _2786_/X _2788_/Y _2823_/Y vssd1 vssd1 vccd1 vccd1 _2850_/A sky130_fd_sc_hd__o21ai_1
X_2756_ _2717_/B _2717_/Y _2754_/X _2755_/Y vssd1 vssd1 vccd1 vccd1 _2758_/B sky130_fd_sc_hd__a211o_1
X_2687_ _2688_/A _2688_/B _2688_/C vssd1 vssd1 vccd1 vccd1 _2724_/B sky130_fd_sc_hd__a21o_1
X_4426_ _4668_/CLK _4426_/D fanout423/X vssd1 vssd1 vccd1 vccd1 hold14/A sky130_fd_sc_hd__dfrtp_1
Xfanout403 fanout404/X vssd1 vssd1 vccd1 vccd1 fanout403/X sky130_fd_sc_hd__clkbuf_2
Xfanout414 fanout424/X vssd1 vssd1 vccd1 vccd1 fanout414/X sky130_fd_sc_hd__clkbuf_2
X_4357_ _4356_/A _4371_/C _4371_/B _4361_/B1 _4356_/Y vssd1 vssd1 vccd1 vccd1 _4357_/X
+ sky130_fd_sc_hd__a311o_1
Xfanout436 fanout439/X vssd1 vssd1 vccd1 vccd1 fanout436/X sky130_fd_sc_hd__clkbuf_4
Xfanout425 fanout427/X vssd1 vssd1 vccd1 vccd1 fanout425/X sky130_fd_sc_hd__buf_2
XANTENNA__4088__C _4100_/C vssd1 vssd1 vccd1 vccd1 sky130_fd_sc_hd__diode_2
X_3308_ _4574_/Q _3308_/B vssd1 vssd1 vccd1 vccd1 _3309_/B sky130_fd_sc_hd__or2_1
X_4288_ _4287_/Y _4286_/X _4285_/X hold227/X _4369_/B1 vssd1 vssd1 vccd1 vccd1 _4764_/D
+ sky130_fd_sc_hd__o32a_1
XFILLER_86_489 vccd1 vssd1 vccd1 vssd1 sky130_ef_sc_hd__decap_12
X_3239_ _4551_/Q _4592_/Q vssd1 vssd1 vccd1 vccd1 _3241_/B sky130_fd_sc_hd__nor2_1
XANTENNA_fanout182_X _4171_/A0 vssd1 vssd1 vccd1 vccd1 sky130_fd_sc_hd__diode_2
XFILLER_46_309 vssd1 vssd1 vccd1 vccd1 sky130_fd_sc_hd__fill_1
XTAP_TAPCELL_ROW_1_198 vssd1 vccd1 sky130_fd_sc_hd__tapvpwrvgnd_1
XANTENNA__4061__A2 _4081_/A2 vssd1 vssd1 vccd1 vccd1 sky130_fd_sc_hd__diode_2
XFILLER_80_48 vccd1 vssd1 vccd1 vssd1 sky130_ef_sc_hd__decap_12
XFILLER_80_15 vssd1 vssd1 vccd1 vccd1 sky130_fd_sc_hd__decap_3
XFILLER_22_250 vssd1 vssd1 vccd1 vccd1 sky130_fd_sc_hd__fill_2
Xfanout87 _3460_/B1 vssd1 vssd1 vccd1 vccd1 _3525_/B1 sky130_fd_sc_hd__dlymetal6s2s_1
Xfanout98 _3735_/S vssd1 vssd1 vccd1 vccd1 _3741_/S sky130_fd_sc_hd__clkbuf_4
XANTENNA__3997__A_N _4064_/C vssd1 vssd1 vccd1 vccd1 sky130_fd_sc_hd__diode_2
XFILLER_10_489 vssd1 vssd1 vccd1 vccd1 sky130_fd_sc_hd__decap_3
XANTENNA_fanout95_X _4411_/S vssd1 vssd1 vccd1 vccd1 sky130_fd_sc_hd__diode_2
XFILLER_49_103 vssd1 vssd1 vccd1 vccd1 sky130_fd_sc_hd__decap_8
XFILLER_49_125 vssd1 vssd1 vccd1 vccd1 sky130_fd_sc_hd__fill_2
XFILLER_77_467 vccd1 vssd1 vccd1 vssd1 sky130_ef_sc_hd__decap_12
XFILLER_49_169 vssd1 vssd1 vccd1 vccd1 sky130_fd_sc_hd__decap_4
XFILLER_64_139 vssd1 vssd1 vccd1 vccd1 sky130_fd_sc_hd__fill_1
XFILLER_72_150 vssd1 vssd1 vccd1 vccd1 sky130_fd_sc_hd__decap_4
XTAP_TAPCELL_ROW_71_830 vssd1 vccd1 sky130_fd_sc_hd__tapvpwrvgnd_1
XTAP_TAPCELL_ROW_43_576 vssd1 vccd1 sky130_fd_sc_hd__tapvpwrvgnd_1
XFILLER_9_221 vssd1 vssd1 vccd1 vccd1 sky130_fd_sc_hd__fill_1
Xclkload24 _4782_/CLK vssd1 vssd1 vccd1 vccd1 clkload24/Y sky130_fd_sc_hd__bufinv_16
XFILLER_70_92 vccd1 vssd1 vccd1 vssd1 sky130_ef_sc_hd__decap_12
Xclkload13 _4808_/CLK vssd1 vssd1 vccd1 vccd1 clkload13/Y sky130_fd_sc_hd__clkinvlp_4
Xclkload35 _4624_/CLK vssd1 vssd1 vccd1 vccd1 clkload35/X sky130_fd_sc_hd__clkbuf_8
X_3590_ _3579_/A _3582_/Y _3587_/Y vssd1 vssd1 vccd1 vccd1 _3590_/Y sky130_fd_sc_hd__a21boi_2
X_2610_ _2610_/A _2610_/B vssd1 vssd1 vccd1 vccd1 _2612_/B sky130_fd_sc_hd__xnor2_1
Xclkload46 _4577_/CLK vssd1 vssd1 vccd1 vccd1 clkload46/Y sky130_fd_sc_hd__inv_6
X_2541_ _2537_/X _2539_/Y _4722_/Q vssd1 vssd1 vccd1 vccd1 _2542_/B sky130_fd_sc_hd__o21bai_1
X_2472_ _4687_/Q _4674_/Q _2458_/B _4660_/Q _2456_/Y vssd1 vssd1 vccd1 vccd1 _2472_/Y
+ sky130_fd_sc_hd__a221oi_2
XFILLER_5_460 vccd1 vssd1 vccd1 vssd1 sky130_ef_sc_hd__decap_12
XFILLER_87_209 vccd1 vssd1 vccd1 vssd1 sky130_ef_sc_hd__decap_12
XFILLER_48_3 vssd1 vssd1 vccd1 vccd1 sky130_fd_sc_hd__decap_8
X_4211_ _4258_/C _4211_/B _4273_/S _4239_/D vssd1 vssd1 vccd1 vccd1 _4211_/X sky130_fd_sc_hd__and4b_1
X_4142_ _4139_/X _4140_/X _4141_/Y _4192_/B1 hold196/X vssd1 vssd1 vccd1 vccd1 _4727_/D
+ sky130_fd_sc_hd__o32a_1
XANTENNA__4409__S _4410_/S vssd1 vssd1 vccd1 vccd1 sky130_fd_sc_hd__diode_2
XFILLER_28_309 vccd1 vssd1 vccd1 vssd1 sky130_ef_sc_hd__decap_12
X_4073_ _4274_/D _4105_/A2 _4192_/B1 vssd1 vssd1 vccd1 vccd1 _4073_/Y sky130_fd_sc_hd__o21ai_1
X_3024_ _3024_/A _3024_/B vssd1 vssd1 vccd1 vccd1 _3025_/B sky130_fd_sc_hd__nor2_1
XFILLER_51_301 vccd1 vssd1 vccd1 vssd1 sky130_ef_sc_hd__decap_12
XANTENNA__3549__A _3549_/A vssd1 vssd1 vccd1 vccd1 sky130_fd_sc_hd__diode_2
X_3926_ _3873_/A _4804_/Q vssd1 vssd1 vccd1 vccd1 _3926_/X sky130_fd_sc_hd__and2b_1
X_3857_ _3154_/Y _3155_/A _3152_/Y vssd1 vssd1 vccd1 vccd1 _3868_/A sky130_fd_sc_hd__a21bo_1
Xclkload7 clkload7/A vssd1 vssd1 vccd1 vccd1 clkload7/Y sky130_fd_sc_hd__clkinv_2
XFILLER_50_29 vssd1 vssd1 vccd1 vccd1 sky130_fd_sc_hd__fill_1
X_3788_ _4647_/Q _4538_/Q vssd1 vssd1 vccd1 vccd1 _3788_/X sky130_fd_sc_hd__and2b_1
XANTENNA_fanout407_A fanout414/X vssd1 vssd1 vccd1 vccd1 sky130_fd_sc_hd__diode_2
X_2808_ hold95/A hold93/A vssd1 vssd1 vccd1 vccd1 _2810_/A sky130_fd_sc_hd__and2_1
X_2739_ _2737_/X _2739_/B vssd1 vssd1 vccd1 vccd1 _2746_/A sky130_fd_sc_hd__nand2b_1
X_4409_ hold145/X input26/X _4410_/S vssd1 vssd1 vccd1 vccd1 _4818_/D sky130_fd_sc_hd__mux2_1
Xfanout200 _2424_/S vssd1 vssd1 vccd1 vccd1 _2420_/S sky130_fd_sc_hd__clkbuf_4
Xfanout222 _3916_/X vssd1 vssd1 vccd1 vccd1 _4279_/A2 sky130_fd_sc_hd__buf_2
Xfanout211 fanout215/X vssd1 vssd1 vccd1 vccd1 _3561_/C sky130_fd_sc_hd__buf_2
XFILLER_86_231 vssd1 vssd1 vccd1 vccd1 sky130_fd_sc_hd__decap_3
Xfanout233 _3896_/X vssd1 vssd1 vccd1 vccd1 _4328_/B sky130_fd_sc_hd__buf_2
Xfanout255 _4278_/A_N vssd1 vssd1 vccd1 vccd1 _3919_/B sky130_fd_sc_hd__buf_1
XTAP_TAPCELL_ROW_6_246 vssd1 vccd1 sky130_fd_sc_hd__tapvpwrvgnd_1
Xfanout244 fanout248/X vssd1 vssd1 vccd1 vccd1 _2365_/S sky130_fd_sc_hd__clkbuf_4
XFILLER_86_275 vccd1 vssd1 vccd1 vssd1 sky130_ef_sc_hd__decap_12
XFILLER_86_253 vssd1 vssd1 vccd1 vccd1 sky130_fd_sc_hd__decap_6
Xfanout299 _4802_/Q vssd1 vssd1 vccd1 vccd1 _4372_/A sky130_fd_sc_hd__buf_2
XFILLER_75_26 vssd1 vssd1 vccd1 vccd1 sky130_fd_sc_hd__fill_1
XFILLER_74_404 vssd1 vssd1 vccd1 vccd1 sky130_fd_sc_hd__fill_1
Xfanout266 _4814_/Q vssd1 vssd1 vccd1 vccd1 _4211_/B sky130_fd_sc_hd__buf_2
Xfanout288 _4809_/Q vssd1 vssd1 vccd1 vccd1 _4009_/A_N sky130_fd_sc_hd__clkbuf_2
Xfanout277 _4811_/Q vssd1 vssd1 vccd1 vccd1 _4132_/C sky130_fd_sc_hd__clkbuf_2
XANTENNA__4319__S _4324_/A vssd1 vssd1 vccd1 vccd1 sky130_fd_sc_hd__diode_2
XFILLER_59_478 vssd1 vssd1 vccd1 vccd1 sky130_fd_sc_hd__decap_4
XFILLER_46_139 vssd1 vssd1 vccd1 vccd1 sky130_fd_sc_hd__fill_1
XTAP_TAPCELL_ROW_85_955 vssd1 vccd1 sky130_fd_sc_hd__tapvpwrvgnd_1
XANTENNA__4025__A_N _4104_/C vssd1 vssd1 vccd1 vccd1 sky130_fd_sc_hd__diode_2
XFILLER_42_334 vccd1 vssd1 vccd1 vssd1 sky130_ef_sc_hd__decap_12
XFILLER_42_356 vssd1 vssd1 vccd1 vccd1 sky130_fd_sc_hd__fill_1
XTAP_TAPCELL_ROW_40_546 vssd1 vccd1 sky130_fd_sc_hd__tapvpwrvgnd_1
XFILLER_10_286 vssd1 vssd1 vccd1 vccd1 sky130_fd_sc_hd__fill_2
XANTENNA__4337__A3 _4328_/B vssd1 vssd1 vccd1 vccd1 sky130_fd_sc_hd__diode_2
XFILLER_6_257 vssd1 vssd1 vccd1 vccd1 sky130_fd_sc_hd__fill_1
XANTENNA__2302__S _4005_/D vssd1 vssd1 vccd1 vccd1 sky130_fd_sc_hd__diode_2
XFILLER_2_452 vccd1 vssd1 vccd1 vssd1 sky130_ef_sc_hd__decap_12
XFILLER_77_231 vssd1 vssd1 vccd1 vccd1 sky130_fd_sc_hd__decap_4
XANTENNA__2538__A _4737_/Q vssd1 vssd1 vccd1 vccd1 sky130_fd_sc_hd__diode_2
XTAP_TAPCELL_ROW_48_624 vssd1 vccd1 sky130_fd_sc_hd__tapvpwrvgnd_1
XFILLER_18_342 vccd1 vssd1 vccd1 vssd1 sky130_ef_sc_hd__decap_12
XFILLER_33_334 vssd1 vssd1 vccd1 vccd1 sky130_fd_sc_hd__fill_2
XTAP_TAPCELL_ROW_56_690 vssd1 vccd1 sky130_fd_sc_hd__tapvpwrvgnd_1
XFILLER_33_367 vccd1 vssd1 vccd1 vssd1 sky130_ef_sc_hd__decap_12
XANTENNA__4191__C _4199_/D vssd1 vssd1 vccd1 vccd1 sky130_fd_sc_hd__diode_2
X_4760_ _4776_/CLK _4760_/D fanout399/X vssd1 vssd1 vccd1 vccd1 _4760_/Q sky130_fd_sc_hd__dfrtp_1
XFILLER_60_197 vccd1 vssd1 vccd1 vssd1 sky130_ef_sc_hd__decap_12
X_4691_ _4808_/CLK _4691_/D fanout378/X vssd1 vssd1 vccd1 vccd1 _4691_/Q sky130_fd_sc_hd__dfrtp_1
X_3711_ _4528_/Q _4637_/Q _3707_/Y _3709_/Y vssd1 vssd1 vccd1 vccd1 _3711_/Y sky130_fd_sc_hd__o211ai_2
X_3642_ _4520_/Q _4629_/Q _3641_/X vssd1 vssd1 vccd1 vccd1 _3642_/X sky130_fd_sc_hd__o21a_1
XTAP_TAPCELL_ROW_11_292 vssd1 vccd1 sky130_fd_sc_hd__tapvpwrvgnd_1
X_3573_ _4511_/Q _4620_/Q _3571_/Y _3572_/Y _3567_/X vssd1 vssd1 vccd1 vccd1 _3573_/X
+ sky130_fd_sc_hd__a221o_1
XPHY_EDGE_ROW_49_Right_49 vssd1 vssd1 vccd1 vccd1 sky130_fd_sc_hd__decap_3
X_2524_ _2533_/A _2533_/B vssd1 vssd1 vccd1 vccd1 _2524_/Y sky130_fd_sc_hd__nor2_1
X_2455_ _4687_/Q _4674_/Q vssd1 vssd1 vccd1 vccd1 _2456_/B sky130_fd_sc_hd__nor2_1
Xhold19 hold19/A vssd1 vssd1 vccd1 vccd1 hold19/X sky130_fd_sc_hd__dlygate4sd3_1
X_2386_ hold32/X _2385_/X _2426_/S vssd1 vssd1 vccd1 vccd1 _4488_/D sky130_fd_sc_hd__mux2_1
XFILLER_68_253 vssd1 vssd1 vccd1 vccd1 sky130_fd_sc_hd__decap_6
XTAP_TAPCELL_ROW_3_216 vssd1 vccd1 sky130_fd_sc_hd__tapvpwrvgnd_1
X_4125_ _4324_/A _4173_/A2 _4130_/B1 vssd1 vssd1 vccd1 vccd1 _4125_/Y sky130_fd_sc_hd__o21ai_1
XANTENNA__4139__S _4273_/S vssd1 vssd1 vccd1 vccd1 sky130_fd_sc_hd__diode_2
X_4056_ _4116_/D _4119_/S _4068_/B _4056_/D vssd1 vssd1 vccd1 vccd1 _4056_/X sky130_fd_sc_hd__and4b_1
XPHY_EDGE_ROW_58_Right_58 vssd1 vssd1 vccd1 vccd1 sky130_fd_sc_hd__decap_3
XTAP_TAPCELL_ROW_82_925 vssd1 vccd1 sky130_fd_sc_hd__tapvpwrvgnd_1
X_3007_ _3003_/X _3007_/B _3007_/C vssd1 vssd1 vccd1 vccd1 _3008_/B sky130_fd_sc_hd__and3b_1
XFILLER_24_301 vssd1 vssd1 vccd1 vccd1 sky130_fd_sc_hd__decap_6
XFILLER_51_131 vssd1 vssd1 vccd1 vccd1 sky130_fd_sc_hd__fill_1
X_3909_ _4007_/B2 _4081_/A2 _3908_/Y vssd1 vssd1 vccd1 vccd1 _4661_/D sky130_fd_sc_hd__a21oi_1
XPHY_EDGE_ROW_67_Right_67 vssd1 vssd1 vccd1 vccd1 sky130_fd_sc_hd__decap_3
XPHY_EDGE_ROW_76_Right_76 vssd1 vssd1 vccd1 vccd1 sky130_fd_sc_hd__decap_3
XFILLER_74_245 vssd1 vssd1 vccd1 vccd1 sky130_fd_sc_hd__decap_6
XFILLER_42_197 vssd1 vssd1 vccd1 vccd1 sky130_fd_sc_hd__fill_2
XPHY_EDGE_ROW_85_Right_85 vssd1 vssd1 vccd1 vccd1 sky130_fd_sc_hd__decap_3
XANTENNA__4176__D1 _4377_/C1 vssd1 vssd1 vccd1 vccd1 sky130_fd_sc_hd__diode_2
X_2240_ hold26/X _3282_/A _2249_/S vssd1 vssd1 vccd1 vccd1 _4419_/D sky130_fd_sc_hd__mux2_1
XFILLER_38_404 vssd1 vssd1 vccd1 vccd1 sky130_fd_sc_hd__fill_2
XFILLER_76_80 vssd1 vssd1 vccd1 vccd1 sky130_fd_sc_hd__decap_4
XFILLER_65_289 vssd1 vssd1 vccd1 vccd1 sky130_fd_sc_hd__decap_3
XFILLER_53_407 vccd1 vssd1 vccd1 vssd1 sky130_ef_sc_hd__decap_12
XFILLER_80_248 vssd1 vssd1 vccd1 vccd1 sky130_fd_sc_hd__decap_4
XANTENNA__3454__B1 _3460_/B1 vssd1 vssd1 vccd1 vccd1 sky130_fd_sc_hd__diode_2
XANTENNA__2274__Y _2274_/Y vssd1 vssd1 vccd1 vccd1 sky130_fd_sc_hd__diode_2
X_4812_ _4815_/CLK _4812_/D fanout394/X vssd1 vssd1 vccd1 vccd1 _4812_/Q sky130_fd_sc_hd__dfrtp_1
XFILLER_21_326 vssd1 vssd1 vccd1 vccd1 sky130_fd_sc_hd__fill_1
XFILLER_21_337 vssd1 vssd1 vccd1 vccd1 sky130_fd_sc_hd__fill_2
XFILLER_33_197 vccd1 vssd1 vccd1 vssd1 sky130_ef_sc_hd__decap_12
X_4743_ _4745_/CLK _4743_/D fanout389/X vssd1 vssd1 vccd1 vccd1 _4743_/Q sky130_fd_sc_hd__dfrtp_1
X_4674_ _4687_/CLK _4674_/D fanout385/X vssd1 vssd1 vccd1 vccd1 _4674_/Q sky130_fd_sc_hd__dfrtp_2
X_3625_ _4518_/Q _4627_/Q _4517_/Q _4626_/Q vssd1 vssd1 vccd1 vccd1 _3625_/X sky130_fd_sc_hd__o211a_1
XANTENNA_fanout105_A _3534_/A2 vssd1 vssd1 vccd1 vccd1 sky130_fd_sc_hd__diode_2
X_3556_ _3558_/A _3551_/X _3553_/Y _3555_/X vssd1 vssd1 vccd1 vccd1 _3556_/X sky130_fd_sc_hd__o31a_1
XANTENNA__4182__A1 _4210_/A1 vssd1 vssd1 vccd1 vccd1 sky130_fd_sc_hd__diode_2
X_2507_ _2533_/A _2507_/B vssd1 vssd1 vccd1 vccd1 _3811_/B sky130_fd_sc_hd__nand2_1
X_3487_ _3487_/A _3487_/B vssd1 vssd1 vccd1 vccd1 _3491_/C sky130_fd_sc_hd__nand2_1
X_2438_ _2438_/A _2438_/B vssd1 vssd1 vccd1 vccd1 _2439_/B sky130_fd_sc_hd__nor2_1
XTAP_TAPCELL_ROW_59_719 vssd1 vccd1 sky130_fd_sc_hd__tapvpwrvgnd_1
X_2369_ _4552_/Q hold80/A _2369_/S vssd1 vssd1 vccd1 vccd1 _2369_/X sky130_fd_sc_hd__mux2_1
XANTENNA__4096__C _4100_/C vssd1 vssd1 vccd1 vccd1 sky130_fd_sc_hd__diode_2
X_4108_ _4238_/S _4175_/C _4361_/B1 vssd1 vssd1 vccd1 vccd1 _4108_/Y sky130_fd_sc_hd__a21oi_1
XFILLER_71_204 vssd1 vssd1 vccd1 vccd1 sky130_fd_sc_hd__fill_1
X_4039_ _4038_/Y _4037_/X _4036_/X _4701_/Q _4039_/B2 vssd1 vssd1 vccd1 vccd1 _4701_/D
+ sky130_fd_sc_hd__o32a_1
XTAP_TAPCELL_ROW_67_796 vssd1 vccd1 sky130_fd_sc_hd__tapvpwrvgnd_1
XANTENNA__3996__A1 _4020_/A1 vssd1 vssd1 vccd1 vccd1 sky130_fd_sc_hd__diode_2
XFILLER_52_473 vssd1 vssd1 vccd1 vccd1 sky130_fd_sc_hd__decap_3
XFILLER_24_197 vssd1 vssd1 vccd1 vccd1 sky130_fd_sc_hd__decap_6
XTAP_TAPCELL_ROW_50_641 vssd1 vccd1 sky130_fd_sc_hd__tapvpwrvgnd_1
XTAP_TAPCELL_ROW_22_387 vssd1 vccd1 sky130_fd_sc_hd__tapvpwrvgnd_1
XANTENNA__4173__A1 _4372_/A vssd1 vssd1 vccd1 vccd1 sky130_fd_sc_hd__diode_2
XFILLER_21_75 vssd1 vssd1 vccd1 vccd1 sky130_fd_sc_hd__fill_2
XFILLER_79_304 vssd1 vssd1 vccd1 vccd1 sky130_fd_sc_hd__fill_1
XANTENNA__3920__A1 _4377_/C1 vssd1 vssd1 vccd1 vccd1 sky130_fd_sc_hd__diode_2
XFILLER_79_348 vccd1 vssd1 vccd1 vssd1 sky130_ef_sc_hd__decap_12
XANTENNA_input35_A s_axis_tuser vssd1 vssd1 vccd1 vccd1 sky130_fd_sc_hd__diode_2
XFILLER_46_83 vssd1 vssd1 vccd1 vccd1 sky130_fd_sc_hd__fill_1
XFILLER_15_153 vccd1 vssd1 vccd1 vssd1 sky130_ef_sc_hd__decap_12
XFILLER_43_451 vssd1 vssd1 vccd1 vccd1 sky130_fd_sc_hd__decap_8
XTAP_TAPCELL_ROW_13_310 vssd1 vccd1 sky130_fd_sc_hd__tapvpwrvgnd_1
XFILLER_11_370 vssd1 vssd1 vccd1 vccd1 sky130_fd_sc_hd__fill_2
XFILLER_7_55 vssd1 vssd1 vccd1 vccd1 sky130_fd_sc_hd__fill_1
X_4390_ _4227_/C input5/X _4406_/S vssd1 vssd1 vccd1 vccd1 _4799_/D sky130_fd_sc_hd__mux2_1
X_3410_ _3225_/A _3225_/B _3406_/B _3406_/C _3233_/Y vssd1 vssd1 vccd1 vccd1 _3410_/Y
+ sky130_fd_sc_hd__o221ai_1
X_3341_ _4583_/Q _3384_/A2 _3395_/B1 _3367_/C1 vssd1 vssd1 vccd1 vccd1 _3341_/X sky130_fd_sc_hd__o211a_1
XANTENNA__3911__A1 _3946_/A2 vssd1 vssd1 vccd1 vccd1 sky130_fd_sc_hd__diode_2
X_3272_ _3354_/B _3354_/A _3271_/Y vssd1 vssd1 vccd1 vccd1 _3273_/A sky130_fd_sc_hd__o21ai_2
XFILLER_87_90 vssd1 vssd1 vccd1 vccd1 sky130_fd_sc_hd__decap_8
X_2223_ _4653_/Q vssd1 vssd1 vccd1 vccd1 _2465_/A sky130_fd_sc_hd__inv_2
XFILLER_38_256 vssd1 vssd1 vccd1 vccd1 sky130_fd_sc_hd__decap_6
XTAP_TAPCELL_ROW_64_766 vssd1 vccd1 sky130_fd_sc_hd__tapvpwrvgnd_1
XFILLER_34_462 vssd1 vssd1 vccd1 vccd1 sky130_fd_sc_hd__fill_1
X_2987_ _4766_/Q _4781_/Q vssd1 vssd1 vccd1 vccd1 _2988_/B sky130_fd_sc_hd__nor2_1
XFILLER_21_167 vssd1 vssd1 vccd1 vccd1 sky130_fd_sc_hd__fill_1
X_4726_ clkload7/A _4726_/D fanout382/X vssd1 vssd1 vccd1 vccd1 _4726_/Q sky130_fd_sc_hd__dfrtp_1
X_4657_ _4776_/CLK _4657_/D fanout391/X vssd1 vssd1 vccd1 vccd1 _4657_/Q sky130_fd_sc_hd__dfrtp_1
X_3608_ _3627_/A _3608_/B _3594_/X vssd1 vssd1 vccd1 vccd1 _3608_/X sky130_fd_sc_hd__or3b_1
XANTENNA__4155__A1 _4167_/A1 vssd1 vssd1 vccd1 vccd1 sky130_fd_sc_hd__diode_2
XFILLER_1_517 vssd1 vssd1 vccd1 vccd1 sky130_fd_sc_hd__fill_2
X_4588_ _4624_/CLK _4588_/D fanout409/X vssd1 vssd1 vccd1 vccd1 _4588_/Q sky130_fd_sc_hd__dfrtp_4
X_3539_ _3327_/Y _3330_/X _3538_/X vssd1 vssd1 vccd1 vccd1 _3539_/X sky130_fd_sc_hd__a21o_1
XANTENNA__2400__S _2424_/S vssd1 vssd1 vccd1 vccd1 sky130_fd_sc_hd__diode_2
XFILLER_76_329 vssd1 vssd1 vccd1 vccd1 sky130_fd_sc_hd__decap_3
XFILLER_29_223 vssd1 vssd1 vccd1 vccd1 sky130_fd_sc_hd__fill_1
XFILLER_83_15 vccd1 vssd1 vccd1 vssd1 sky130_ef_sc_hd__decap_12
XFILLER_17_407 vssd1 vssd1 vccd1 vccd1 sky130_fd_sc_hd__fill_1
XTAP_TAPCELL_ROW_27_435 vssd1 vccd1 sky130_fd_sc_hd__tapvpwrvgnd_1
XANTENNA__4327__S _4332_/A vssd1 vssd1 vccd1 vccd1 sky130_fd_sc_hd__diode_2
XFILLER_16_53 vssd1 vssd1 vccd1 vccd1 sky130_fd_sc_hd__decap_6
XANTENNA__3969__A1 _4037_/D vssd1 vssd1 vccd1 vccd1 sky130_fd_sc_hd__diode_2
XFILLER_32_85 vssd1 vssd1 vccd1 vccd1 sky130_fd_sc_hd__fill_1
XFILLER_79_101 vssd1 vssd1 vccd1 vccd1 sky130_fd_sc_hd__fill_1
XFILLER_4_377 vssd1 vssd1 vccd1 vccd1 sky130_fd_sc_hd__decap_4
XANTENNA__2310__S _4075_/S vssd1 vssd1 vccd1 vccd1 sky130_fd_sc_hd__diode_2
XANTENNA_clkload0_A clkload0/A vssd1 vssd1 vccd1 vccd1 sky130_fd_sc_hd__diode_2
XTAP_TAPCELL_ROW_61_736 vssd1 vccd1 sky130_fd_sc_hd__tapvpwrvgnd_1
X_2910_ _4748_/Q _4718_/Q vssd1 vssd1 vccd1 vccd1 _2911_/A sky130_fd_sc_hd__nor2_1
XFILLER_16_473 vssd1 vssd1 vccd1 vccd1 sky130_fd_sc_hd__decap_3
XANTENNA__4183__D _4313_/S vssd1 vssd1 vccd1 vccd1 sky130_fd_sc_hd__diode_2
X_3890_ _4214_/A0 hold137/X _3890_/S vssd1 vssd1 vccd1 vccd1 _4655_/D sky130_fd_sc_hd__mux2_1
X_2841_ _2840_/A _2840_/B _2840_/C vssd1 vssd1 vccd1 vccd1 _2842_/B sky130_fd_sc_hd__a21oi_1
X_2772_ _2771_/C _2771_/A _2771_/B vssd1 vssd1 vccd1 vccd1 _2775_/B sky130_fd_sc_hd__o21a_1
X_4511_ _4669_/CLK _4511_/D fanout406/X vssd1 vssd1 vccd1 vccd1 _4511_/Q sky130_fd_sc_hd__dfrtp_1
X_4442_ _4575_/CLK _4442_/D fanout436/X vssd1 vssd1 vccd1 vccd1 hold89/A sky130_fd_sc_hd__dfrtp_1
Xhold116 _4459_/Q vssd1 vssd1 vccd1 vccd1 hold116/X sky130_fd_sc_hd__dlygate4sd3_1
XFILLER_7_193 vssd1 vssd1 vccd1 vccd1 sky130_fd_sc_hd__fill_1
Xhold105 _4658_/Q vssd1 vssd1 vccd1 vccd1 hold105/X sky130_fd_sc_hd__dlygate4sd3_1
XANTENNA__4137__A1 _4203_/C vssd1 vssd1 vccd1 vccd1 sky130_fd_sc_hd__diode_2
Xhold127 _4640_/Q vssd1 vssd1 vccd1 vccd1 hold127/X sky130_fd_sc_hd__dlygate4sd3_1
Xhold138 _4464_/Q vssd1 vssd1 vccd1 vccd1 hold138/X sky130_fd_sc_hd__dlygate4sd3_1
Xhold149 _4708_/Q vssd1 vssd1 vccd1 vccd1 hold149/X sky130_fd_sc_hd__dlygate4sd3_1
X_4373_ _4819_/Q _4373_/B _4374_/S vssd1 vssd1 vccd1 vccd1 _4373_/X sky130_fd_sc_hd__or3b_1
X_3324_ _4577_/Q _4578_/Q vssd1 vssd1 vccd1 vccd1 _3324_/X sky130_fd_sc_hd__or2_1
XPHY_EDGE_ROW_13_Left_101 vssd1 vssd1 vccd1 vccd1 sky130_fd_sc_hd__decap_3
XTAP_TAPCELL_ROW_69_814 vssd1 vccd1 sky130_fd_sc_hd__tapvpwrvgnd_1
X_3255_ _4547_/Q _4588_/Q vssd1 vssd1 vccd1 vccd1 _3370_/A sky130_fd_sc_hd__nand2_1
XFILLER_58_329 vssd1 vssd1 vccd1 vccd1 sky130_fd_sc_hd__decap_4
X_2206_ _4468_/Q vssd1 vssd1 vccd1 vccd1 _2872_/A sky130_fd_sc_hd__inv_2
X_3186_ _3301_/C _3178_/Y _3301_/D _3185_/Y vssd1 vssd1 vccd1 vccd1 _3188_/B sky130_fd_sc_hd__o31a_1
XFILLER_81_332 vssd1 vssd1 vccd1 vccd1 sky130_fd_sc_hd__decap_4
XFILLER_81_321 vssd1 vssd1 vccd1 vccd1 sky130_fd_sc_hd__fill_1
XTAP_TAPCELL_ROW_77_880 vssd1 vccd1 sky130_fd_sc_hd__tapvpwrvgnd_1
XANTENNA__4147__S _4352_/A vssd1 vssd1 vccd1 vccd1 sky130_fd_sc_hd__diode_2
XFILLER_26_259 vssd1 vssd1 vccd1 vccd1 sky130_fd_sc_hd__decap_8
XPHY_EDGE_ROW_22_Left_110 vssd1 vssd1 vccd1 vccd1 sky130_fd_sc_hd__decap_3
XTAP_TAPCELL_ROW_24_405 vssd1 vccd1 sky130_fd_sc_hd__tapvpwrvgnd_1
XFILLER_22_421 vccd1 vssd1 vccd1 vssd1 sky130_ef_sc_hd__decap_12
XFILLER_22_465 vssd1 vssd1 vccd1 vccd1 sky130_fd_sc_hd__fill_1
X_4709_ clkload6/A _4709_/D fanout380/X vssd1 vssd1 vccd1 vccd1 _4709_/Q sky130_fd_sc_hd__dfrtp_1
XFILLER_1_369 vccd1 vssd1 vccd1 vssd1 sky130_ef_sc_hd__decap_12
XFILLER_57_362 vccd1 vssd1 vccd1 vssd1 sky130_ef_sc_hd__decap_12
XFILLER_13_432 vssd1 vssd1 vccd1 vccd1 sky130_fd_sc_hd__decap_8
XFILLER_40_295 vssd1 vssd1 vccd1 vccd1 sky130_fd_sc_hd__decap_4
XANTENNA__4119__A1 _4171_/A1 vssd1 vssd1 vccd1 vccd1 sky130_fd_sc_hd__diode_2
XFILLER_4_78 vssd1 vssd1 vccd1 vccd1 sky130_fd_sc_hd__fill_1
X_3040_ _3055_/A _3038_/X _2988_/Y _2998_/A vssd1 vssd1 vccd1 vccd1 _3041_/B sky130_fd_sc_hd__a211o_1
XFILLER_48_373 vssd1 vssd1 vccd1 vccd1 sky130_fd_sc_hd__decap_3
XFILLER_48_395 vccd1 vssd1 vccd1 vssd1 sky130_ef_sc_hd__decap_12
XANTENNA__4055__A0 _4099_/A0 vssd1 vssd1 vccd1 vccd1 sky130_fd_sc_hd__diode_2
X_3942_ _4332_/A _3900_/X _3900_/B _4674_/Q vssd1 vssd1 vccd1 vccd1 _3942_/X sky130_fd_sc_hd__a2bb2o_1
X_3873_ _3873_/A _4804_/Q vssd1 vssd1 vccd1 vccd1 _3873_/Y sky130_fd_sc_hd__nand2_4
X_2824_ _2786_/X _2788_/Y _2823_/Y vssd1 vssd1 vccd1 vccd1 _2827_/A sky130_fd_sc_hd__o21a_1
X_2755_ _2754_/B _2754_/C _2754_/A vssd1 vssd1 vccd1 vccd1 _2755_/Y sky130_fd_sc_hd__a21oi_1
X_2686_ _2688_/A _2688_/B _2688_/C vssd1 vssd1 vccd1 vccd1 _2689_/A sky130_fd_sc_hd__a21oi_1
X_4425_ _4820_/CLK _4425_/D fanout419/X vssd1 vssd1 vccd1 vccd1 hold6/A sky130_fd_sc_hd__dfrtp_1
X_4356_ _4356_/A _4372_/B vssd1 vssd1 vccd1 vccd1 _4356_/Y sky130_fd_sc_hd__nor2_1
Xfanout404 fanout405/X vssd1 vssd1 vccd1 vccd1 fanout404/X sky130_fd_sc_hd__clkbuf_2
X_3307_ _4574_/Q _3308_/B vssd1 vssd1 vccd1 vccd1 _3307_/X sky130_fd_sc_hd__and2_1
Xfanout437 fanout439/X vssd1 vssd1 vccd1 vccd1 fanout437/X sky130_fd_sc_hd__clkbuf_4
Xfanout415 fanout416/X vssd1 vssd1 vccd1 vccd1 fanout415/X sky130_fd_sc_hd__clkbuf_4
Xfanout426 fanout427/X vssd1 vssd1 vccd1 vccd1 fanout426/X sky130_fd_sc_hd__clkbuf_4
XANTENNA__4088__D _4223_/C vssd1 vssd1 vccd1 vccd1 sky130_fd_sc_hd__diode_2
X_4287_ _4352_/A _4307_/A2 _4358_/A2 vssd1 vssd1 vccd1 vccd1 _4287_/Y sky130_fd_sc_hd__o21ai_1
XANTENNA_fanout387_A fanout388/X vssd1 vssd1 vccd1 vccd1 sky130_fd_sc_hd__diode_2
X_3238_ _4551_/Q _4592_/Q vssd1 vssd1 vccd1 vccd1 _3242_/A sky130_fd_sc_hd__nand2_1
X_3169_ _4570_/Q _4611_/Q vssd1 vssd1 vccd1 vccd1 _3169_/Y sky130_fd_sc_hd__nor2_1
XFILLER_81_140 vssd1 vssd1 vccd1 vccd1 sky130_fd_sc_hd__decap_8
XTAP_TAPCELL_ROW_1_199 vssd1 vccd1 sky130_fd_sc_hd__tapvpwrvgnd_1
XFILLER_54_365 vccd1 vssd1 vccd1 vssd1 sky130_ef_sc_hd__decap_12
XANTENNA_fanout342_X _4120_/D vssd1 vssd1 vccd1 vccd1 sky130_fd_sc_hd__diode_2
XFILLER_80_27 vssd1 vssd1 vccd1 vccd1 sky130_fd_sc_hd__fill_1
Xfanout99 _3543_/Y vssd1 vssd1 vccd1 vccd1 _3735_/S sky130_fd_sc_hd__buf_2
Xfanout88 _3332_/Y vssd1 vssd1 vccd1 vccd1 _3460_/B1 sky130_fd_sc_hd__buf_2
XTAP_TAPCELL_ROW_9_266 vssd1 vccd1 sky130_fd_sc_hd__tapvpwrvgnd_1
XFILLER_8_3 vssd1 vssd1 vccd1 vccd1 sky130_fd_sc_hd__fill_1
XANTENNA_fanout88_X _3460_/B1 vssd1 vssd1 vccd1 vccd1 sky130_fd_sc_hd__diode_2
XFILLER_77_457 vssd1 vssd1 vccd1 vccd1 sky130_fd_sc_hd__fill_1
XFILLER_77_446 vssd1 vssd1 vccd1 vccd1 sky130_fd_sc_hd__fill_2
XFILLER_77_479 vssd1 vssd1 vccd1 vccd1 sky130_fd_sc_hd__decap_4
XFILLER_64_107 vssd1 vssd1 vccd1 vccd1 sky130_fd_sc_hd__fill_1
XFILLER_38_62 vssd1 vssd1 vccd1 vccd1 sky130_fd_sc_hd__fill_1
XFILLER_72_162 vssd1 vssd1 vccd1 vccd1 sky130_fd_sc_hd__fill_2
XFILLER_33_505 vssd1 vssd1 vccd1 vccd1 sky130_fd_sc_hd__fill_1
XTAP_TAPCELL_ROW_71_831 vssd1 vccd1 sky130_fd_sc_hd__tapvpwrvgnd_1
XFILLER_9_200 vssd1 vssd1 vccd1 vccd1 sky130_fd_sc_hd__fill_1
XTAP_TAPCELL_ROW_43_577 vssd1 vccd1 sky130_fd_sc_hd__tapvpwrvgnd_1
Xclkload25 _4819_/CLK vssd1 vssd1 vccd1 vccd1 clkload25/Y sky130_fd_sc_hd__bufinv_16
XFILLER_70_82 vssd1 vssd1 vccd1 vccd1 sky130_fd_sc_hd__fill_2
Xclkload14 _4794_/CLK vssd1 vssd1 vccd1 vccd1 clkload14/Y sky130_fd_sc_hd__clkinv_2
Xclkload47 _4580_/CLK vssd1 vssd1 vccd1 vccd1 clkload47/Y sky130_fd_sc_hd__clkinv_8
X_2540_ _2539_/Y _4722_/Q _2588_/A vssd1 vssd1 vccd1 vccd1 _2588_/B sky130_fd_sc_hd__nand3b_2
Xclkload36 _4593_/CLK vssd1 vssd1 vccd1 vccd1 clkload36/Y sky130_fd_sc_hd__inv_8
XFILLER_5_472 vccd1 vssd1 vccd1 vssd1 sky130_ef_sc_hd__decap_12
X_2471_ _4687_/Q _4674_/Q _4455_/Q _4660_/Q vssd1 vssd1 vccd1 vccd1 _2471_/Y sky130_fd_sc_hd__nand4_1
X_4210_ _4238_/A0 _4210_/A1 _4215_/C vssd1 vssd1 vccd1 vccd1 _4210_/X sky130_fd_sc_hd__mux2_1
X_4141_ _4274_/D _4176_/A2 _4192_/B1 vssd1 vssd1 vccd1 vccd1 _4141_/Y sky130_fd_sc_hd__o21ai_1
X_4072_ _4132_/C _4810_/Q _4100_/C _4274_/D vssd1 vssd1 vccd1 vccd1 _4072_/X sky130_fd_sc_hd__and4b_1
XFILLER_83_449 vssd1 vssd1 vccd1 vccd1 sky130_fd_sc_hd__decap_3
X_3023_ _3023_/A _4752_/Q vssd1 vssd1 vccd1 vccd1 _3024_/B sky130_fd_sc_hd__nor2_1
XFILLER_36_321 vccd1 vssd1 vccd1 vssd1 sky130_ef_sc_hd__decap_12
XFILLER_51_313 vssd1 vssd1 vccd1 vccd1 sky130_fd_sc_hd__decap_6
X_3925_ hold57/X hold67/A _3925_/S vssd1 vssd1 vccd1 vccd1 hold58/A sky130_fd_sc_hd__mux2_1
X_3856_ _4646_/Q _3869_/S _3855_/Y vssd1 vssd1 vccd1 vccd1 _4646_/D sky130_fd_sc_hd__a21o_1
XANTENNA_fanout135_A _3922_/B1 vssd1 vssd1 vccd1 vccd1 sky130_fd_sc_hd__diode_2
Xclkload8 clkload8/A vssd1 vssd1 vccd1 vccd1 clkload8/Y sky130_fd_sc_hd__inv_6
X_3787_ _4538_/Q _4647_/Q vssd1 vssd1 vccd1 vccd1 _3787_/X sky130_fd_sc_hd__and2b_1
X_2807_ _2806_/A _2806_/B _2806_/C vssd1 vssd1 vccd1 vccd1 _2812_/B sky130_fd_sc_hd__a21oi_1
XANTENNA_fanout302_A _4801_/Q vssd1 vssd1 vccd1 vccd1 sky130_fd_sc_hd__diode_2
X_2738_ _2785_/A _2730_/X _2735_/Y _2736_/X vssd1 vssd1 vccd1 vccd1 _2739_/B sky130_fd_sc_hd__a211o_1
X_4408_ _3919_/B input24/X _4408_/S vssd1 vssd1 vccd1 vccd1 _4817_/D sky130_fd_sc_hd__mux2_1
X_2669_ _2669_/A _2669_/B vssd1 vssd1 vccd1 vccd1 _2674_/A sky130_fd_sc_hd__nand2_1
Xfanout223 _3916_/X vssd1 vssd1 vccd1 vccd1 _4307_/A2 sky130_fd_sc_hd__clkbuf_2
Xfanout212 fanout215/X vssd1 vssd1 vccd1 vccd1 _3367_/C1 sky130_fd_sc_hd__clkbuf_2
Xfanout201 _2346_/X vssd1 vssd1 vccd1 vccd1 _2424_/S sky130_fd_sc_hd__buf_2
Xfanout256 _4817_/Q vssd1 vssd1 vccd1 vccd1 _4278_/A_N sky130_fd_sc_hd__buf_1
X_4339_ _4339_/A0 _4343_/A1 _4344_/A vssd1 vssd1 vccd1 vccd1 _4339_/X sky130_fd_sc_hd__mux2_1
Xfanout234 _2275_/X vssd1 vssd1 vccd1 vccd1 _2295_/B sky130_fd_sc_hd__buf_2
XTAP_TAPCELL_ROW_6_247 vssd1 vccd1 sky130_fd_sc_hd__tapvpwrvgnd_1
XANTENNA_fanout292_X _4037_/C vssd1 vssd1 vccd1 vccd1 sky130_fd_sc_hd__diode_2
Xfanout245 _2419_/S vssd1 vssd1 vccd1 vccd1 _2425_/S sky130_fd_sc_hd__clkbuf_4
Xfanout289 _4001_/B vssd1 vssd1 vccd1 vccd1 _4037_/B sky130_fd_sc_hd__clkbuf_2
Xfanout267 _4813_/Q vssd1 vssd1 vccd1 vccd1 _4199_/D sky130_fd_sc_hd__clkbuf_2
Xfanout278 _4811_/Q vssd1 vssd1 vccd1 vccd1 _4168_/C sky130_fd_sc_hd__clkbuf_2
XFILLER_86_287 vccd1 vssd1 vccd1 vssd1 sky130_ef_sc_hd__decap_12
XFILLER_75_49 vssd1 vssd1 vccd1 vccd1 sky130_fd_sc_hd__fill_1
XTAP_TAPCELL_ROW_85_956 vssd1 vccd1 sky130_fd_sc_hd__tapvpwrvgnd_1
XFILLER_27_321 vccd1 vssd1 vccd1 vssd1 sky130_ef_sc_hd__decap_12
XFILLER_39_181 vssd1 vssd1 vccd1 vccd1 sky130_fd_sc_hd__decap_6
XFILLER_82_471 vssd1 vssd1 vccd1 vccd1 sky130_fd_sc_hd__decap_4
XFILLER_15_505 vssd1 vssd1 vccd1 vccd1 sky130_fd_sc_hd__fill_1
XFILLER_42_346 vssd1 vssd1 vccd1 vccd1 sky130_fd_sc_hd__fill_2
XANTENNA__4335__S _4340_/A vssd1 vssd1 vccd1 vccd1 sky130_fd_sc_hd__diode_2
XTAP_TAPCELL_ROW_40_547 vssd1 vccd1 sky130_fd_sc_hd__tapvpwrvgnd_1
XFILLER_40_85 vccd1 vssd1 vccd1 vssd1 sky130_ef_sc_hd__decap_12
XFILLER_2_464 vccd1 vssd1 vccd1 vssd1 sky130_ef_sc_hd__decap_12
XFILLER_77_276 vssd1 vssd1 vccd1 vccd1 sky130_fd_sc_hd__decap_4
XTAP_TAPCELL_ROW_48_625 vssd1 vccd1 sky130_fd_sc_hd__tapvpwrvgnd_1
XFILLER_18_321 vssd1 vssd1 vccd1 vccd1 sky130_fd_sc_hd__decap_8
XFILLER_80_419 vssd1 vssd1 vccd1 vccd1 sky130_fd_sc_hd__fill_1
XFILLER_18_354 vssd1 vssd1 vccd1 vccd1 sky130_fd_sc_hd__decap_8
XFILLER_18_365 vssd1 vssd1 vccd1 vccd1 sky130_fd_sc_hd__fill_1
XFILLER_73_482 vccd1 vssd1 vccd1 vssd1 sky130_ef_sc_hd__decap_12
XFILLER_33_346 vssd1 vssd1 vccd1 vccd1 sky130_fd_sc_hd__fill_1
XTAP_TAPCELL_ROW_56_691 vssd1 vccd1 sky130_fd_sc_hd__tapvpwrvgnd_1
XFILLER_33_379 vssd1 vssd1 vccd1 vccd1 sky130_fd_sc_hd__decap_4
XANTENNA__2273__B _2274_/B vssd1 vssd1 vccd1 vccd1 sky130_fd_sc_hd__diode_2
XANTENNA__4191__D _4324_/A vssd1 vssd1 vccd1 vccd1 sky130_fd_sc_hd__diode_2
X_3710_ _3729_/C _3709_/A _4637_/Q _4528_/Q vssd1 vssd1 vccd1 vccd1 _3710_/X sky130_fd_sc_hd__o2bb2a_1
X_4690_ _4806_/CLK _4690_/D fanout385/X vssd1 vssd1 vccd1 vccd1 _4690_/Q sky130_fd_sc_hd__dfrtp_1
X_3641_ _4519_/Q _4628_/Q _4520_/Q _4629_/Q vssd1 vssd1 vccd1 vccd1 _3641_/X sky130_fd_sc_hd__a22o_1
X_3572_ _3572_/A _3572_/B vssd1 vssd1 vccd1 vccd1 _3572_/Y sky130_fd_sc_hd__nand2_1
XFILLER_60_3 vssd1 vssd1 vccd1 vccd1 sky130_fd_sc_hd__fill_1
X_2523_ _2523_/A _2523_/B vssd1 vssd1 vccd1 vccd1 _2533_/B sky130_fd_sc_hd__nand2_1
X_2454_ _4687_/Q _4674_/Q vssd1 vssd1 vccd1 vccd1 _2470_/C sky130_fd_sc_hd__and2_1
XFILLER_68_221 vssd1 vssd1 vccd1 vccd1 sky130_fd_sc_hd__decap_6
X_2385_ _4560_/Q hold73/A _2425_/S vssd1 vssd1 vccd1 vccd1 _2385_/X sky130_fd_sc_hd__mux2_1
XFILLER_68_265 vccd1 vssd1 vccd1 vssd1 sky130_ef_sc_hd__decap_12
XTAP_TAPCELL_ROW_3_217 vssd1 vccd1 sky130_fd_sc_hd__tapvpwrvgnd_1
X_4124_ _4199_/D _4136_/B _4132_/C _4324_/A vssd1 vssd1 vccd1 vccd1 _4124_/X sky130_fd_sc_hd__and4b_1
XFILLER_83_213 vssd1 vssd1 vccd1 vccd1 sky130_fd_sc_hd__decap_8
Xinput1 m_axis_tready vssd1 vssd1 vccd1 vccd1 input1/X sky130_fd_sc_hd__buf_1
X_4055_ _4099_/A0 _4083_/A1 _4123_/S vssd1 vssd1 vccd1 vccd1 _4055_/X sky130_fd_sc_hd__mux2_1
Xclkbuf_leaf_48_clk clkload0/A vssd1 vssd1 vccd1 vccd1 _4687_/CLK sky130_fd_sc_hd__clkbuf_8
XFILLER_83_268 vccd1 vssd1 vccd1 vssd1 sky130_ef_sc_hd__decap_12
XTAP_TAPCELL_ROW_82_926 vssd1 vccd1 sky130_fd_sc_hd__tapvpwrvgnd_1
X_3006_ _3007_/B _3007_/C _3003_/X vssd1 vssd1 vccd1 vccd1 _3008_/A sky130_fd_sc_hd__a21boi_1
XTAP_TAPCELL_ROW_19_360 vssd1 vccd1 sky130_fd_sc_hd__tapvpwrvgnd_1
XFILLER_36_195 vssd1 vssd1 vccd1 vccd1 sky130_fd_sc_hd__fill_1
XANTENNA__4155__S _4227_/C vssd1 vssd1 vccd1 vccd1 sky130_fd_sc_hd__diode_2
X_3908_ _3946_/A2 _3946_/A1 hold101/X vssd1 vssd1 vccd1 vccd1 _3908_/Y sky130_fd_sc_hd__a21oi_1
X_3839_ _2944_/X _2954_/Y _2955_/Y vssd1 vssd1 vccd1 vccd1 _3839_/Y sky130_fd_sc_hd__a21oi_1
XANTENNA__2403__S _2421_/S vssd1 vssd1 vccd1 vccd1 sky130_fd_sc_hd__diode_2
XANTENNA_fanout305_X _4364_/A vssd1 vssd1 vccd1 vccd1 sky130_fd_sc_hd__diode_2
XFILLER_86_15 vccd1 vssd1 vccd1 vssd1 sky130_ef_sc_hd__decap_12
XFILLER_59_221 vssd1 vssd1 vccd1 vccd1 sky130_fd_sc_hd__decap_3
XFILLER_59_254 vccd1 vssd1 vccd1 vssd1 sky130_ef_sc_hd__decap_12
XFILLER_19_42 vssd1 vssd1 vccd1 vccd1 sky130_fd_sc_hd__fill_1
XFILLER_19_53 vssd1 vssd1 vccd1 vccd1 sky130_fd_sc_hd__fill_1
XFILLER_47_405 vccd1 vssd1 vccd1 vssd1 sky130_ef_sc_hd__decap_12
Xclkbuf_leaf_39_clk clkload2/A vssd1 vssd1 vccd1 vccd1 _4549_/CLK sky130_fd_sc_hd__clkbuf_8
XFILLER_47_449 vssd1 vssd1 vccd1 vccd1 sky130_fd_sc_hd__decap_8
XFILLER_74_268 vssd1 vssd1 vccd1 vccd1 sky130_fd_sc_hd__fill_1
XFILLER_82_290 vssd1 vssd1 vccd1 vccd1 sky130_fd_sc_hd__decap_8
XFILLER_15_335 vssd1 vssd1 vccd1 vccd1 sky130_fd_sc_hd__fill_1
XFILLER_7_501 vssd1 vssd1 vccd1 vccd1 sky130_fd_sc_hd__fill_1
XANTENNA__3518__A2 _3522_/A2 vssd1 vssd1 vccd1 vccd1 sky130_fd_sc_hd__diode_2
XANTENNA__4176__C1 _4377_/B1 vssd1 vssd1 vccd1 vccd1 sky130_fd_sc_hd__diode_2
XFILLER_65_202 vccd1 vssd1 vccd1 vssd1 sky130_ef_sc_hd__decap_12
XPHY_EDGE_ROW_69_Left_157 vssd1 vssd1 vccd1 vccd1 sky130_fd_sc_hd__decap_3
XFILLER_65_279 vssd1 vssd1 vccd1 vccd1 sky130_fd_sc_hd__fill_1
XANTENNA__3454__A1 _3460_/A1 vssd1 vssd1 vccd1 vccd1 sky130_fd_sc_hd__diode_2
XFILLER_53_419 vccd1 vssd1 vccd1 vssd1 sky130_ef_sc_hd__decap_12
XFILLER_33_110 vssd1 vssd1 vccd1 vccd1 sky130_fd_sc_hd__fill_2
XTAP_TAPCELL_ROW_16_330 vssd1 vccd1 sky130_fd_sc_hd__tapvpwrvgnd_1
X_4811_ clkload3/A _4811_/D fanout379/X vssd1 vssd1 vccd1 vccd1 _4811_/Q sky130_fd_sc_hd__dfrtp_1
XFILLER_33_121 vssd1 vssd1 vccd1 vccd1 sky130_fd_sc_hd__fill_2
XFILLER_33_165 vssd1 vssd1 vccd1 vccd1 sky130_fd_sc_hd__decap_3
X_4742_ _4745_/CLK _4742_/D fanout389/X vssd1 vssd1 vccd1 vccd1 _4742_/Q sky130_fd_sc_hd__dfrtp_1
X_4673_ _4687_/CLK _4673_/D fanout383/X vssd1 vssd1 vccd1 vccd1 _4673_/Q sky130_fd_sc_hd__dfrtp_1
XPHY_EDGE_ROW_78_Left_166 vssd1 vssd1 vccd1 vccd1 sky130_fd_sc_hd__decap_3
XANTENNA__3509__A2 _3534_/A2 vssd1 vssd1 vccd1 vccd1 sky130_fd_sc_hd__diode_2
X_3624_ _4518_/Q _4627_/Q _3623_/X vssd1 vssd1 vccd1 vccd1 _3657_/C sky130_fd_sc_hd__o21a_1
X_3555_ _3555_/A _3613_/B _3561_/C vssd1 vssd1 vccd1 vccd1 _3555_/X sky130_fd_sc_hd__and3_1
X_3486_ _3487_/B _3487_/A vssd1 vssd1 vccd1 vccd1 _3486_/X sky130_fd_sc_hd__or2_1
X_2506_ _4704_/Q _2483_/B _2505_/A _2482_/A vssd1 vssd1 vccd1 vccd1 _2507_/B sky130_fd_sc_hd__a211o_1
XANTENNA__3390__B1 _3541_/B1 vssd1 vssd1 vccd1 vccd1 sky130_fd_sc_hd__diode_2
X_2437_ _4672_/Q _4453_/Q vssd1 vssd1 vccd1 vccd1 _2438_/B sky130_fd_sc_hd__nor2_1
XPHY_EDGE_ROW_87_Left_175 vssd1 vssd1 vccd1 vccd1 sky130_fd_sc_hd__decap_3
X_2368_ hold82/X _2367_/X _2382_/S vssd1 vssd1 vccd1 vccd1 _4479_/D sky130_fd_sc_hd__mux2_1
XANTENNA__4096__D _4231_/C vssd1 vssd1 vccd1 vccd1 sky130_fd_sc_hd__diode_2
X_2299_ _4064_/D _2323_/B vssd1 vssd1 vccd1 vccd1 _2299_/Y sky130_fd_sc_hd__nor2_1
X_4107_ _4044_/C _4120_/C _4044_/B _4036_/S vssd1 vssd1 vccd1 vccd1 _4107_/X sky130_fd_sc_hd__a22o_1
XFILLER_56_224 vccd1 vssd1 vccd1 vssd1 sky130_ef_sc_hd__decap_12
X_4038_ _4037_/D _4038_/A2 _4038_/B1 vssd1 vssd1 vccd1 vccd1 _4038_/Y sky130_fd_sc_hd__o21ai_1
XFILLER_71_216 vssd1 vssd1 vccd1 vccd1 sky130_fd_sc_hd__fill_2
XFILLER_12_305 vssd1 vssd1 vccd1 vccd1 sky130_fd_sc_hd__decap_3
XFILLER_52_485 vssd1 vssd1 vccd1 vccd1 sky130_fd_sc_hd__decap_6
XFILLER_8_309 vssd1 vssd1 vccd1 vccd1 sky130_fd_sc_hd__fill_1
XTAP_TAPCELL_ROW_50_642 vssd1 vccd1 sky130_fd_sc_hd__tapvpwrvgnd_1
XTAP_TAPCELL_ROW_22_388 vssd1 vccd1 sky130_fd_sc_hd__tapvpwrvgnd_1
XANTENNA__4173__A2 _4173_/A2 vssd1 vssd1 vccd1 vccd1 sky130_fd_sc_hd__diode_2
XANTENNA__3920__A2 _4377_/B1 vssd1 vssd1 vccd1 vccd1 sky130_fd_sc_hd__diode_2
XFILLER_87_393 vssd1 vssd1 vccd1 vccd1 sky130_fd_sc_hd__fill_2
XANTENNA_input28_A s_axis_tdata[3] vssd1 vssd1 vccd1 vccd1 sky130_fd_sc_hd__diode_2
XFILLER_62_205 vssd1 vssd1 vccd1 vccd1 sky130_fd_sc_hd__fill_1
XFILLER_47_279 vssd1 vssd1 vccd1 vccd1 sky130_fd_sc_hd__fill_1
XFILLER_70_271 vssd1 vssd1 vccd1 vccd1 sky130_fd_sc_hd__fill_1
XFILLER_15_165 vssd1 vssd1 vccd1 vccd1 sky130_fd_sc_hd__decap_3
XFILLER_70_293 vssd1 vssd1 vccd1 vccd1 sky130_fd_sc_hd__fill_1
XFILLER_11_393 vssd1 vssd1 vccd1 vccd1 sky130_fd_sc_hd__fill_1
XFILLER_7_331 vssd1 vssd1 vccd1 vccd1 sky130_fd_sc_hd__decap_4
X_3340_ _3383_/A1 _3338_/X _3339_/X _3383_/B1 vssd1 vssd1 vccd1 vccd1 _3340_/X sky130_fd_sc_hd__a31o_1
XANTENNA__3911__A2 _3946_/A1 vssd1 vssd1 vccd1 vccd1 sky130_fd_sc_hd__diode_2
X_3271_ _4546_/Q _4587_/Q _4586_/Q _4545_/Q vssd1 vssd1 vccd1 vccd1 _3271_/Y sky130_fd_sc_hd__a22oi_1
X_2222_ _4654_/Q vssd1 vssd1 vccd1 vccd1 _2497_/A sky130_fd_sc_hd__inv_2
XFILLER_38_268 vssd1 vssd1 vccd1 vccd1 sky130_fd_sc_hd__fill_2
XFILLER_38_279 vssd1 vssd1 vccd1 vccd1 sky130_fd_sc_hd__fill_1
XFILLER_53_238 vssd1 vssd1 vccd1 vccd1 sky130_fd_sc_hd__fill_1
XTAP_TAPCELL_ROW_64_767 vssd1 vccd1 sky130_fd_sc_hd__tapvpwrvgnd_1
XANTENNA__3978__A2 _4020_/A1 vssd1 vssd1 vccd1 vccd1 sky130_fd_sc_hd__diode_2
XFILLER_34_430 vssd1 vssd1 vccd1 vccd1 sky130_fd_sc_hd__fill_1
X_2986_ _4766_/Q _4781_/Q vssd1 vssd1 vccd1 vccd1 _3033_/B sky130_fd_sc_hd__and2_1
X_4725_ clkload7/A _4725_/D fanout382/X vssd1 vssd1 vccd1 vccd1 _4725_/Q sky130_fd_sc_hd__dfrtp_1
X_4656_ _4776_/CLK _4656_/D fanout399/X vssd1 vssd1 vccd1 vccd1 _4656_/Q sky130_fd_sc_hd__dfrtp_1
X_4587_ _4587_/CLK _4587_/D fanout409/X vssd1 vssd1 vccd1 vccd1 _4587_/Q sky130_fd_sc_hd__dfrtp_1
X_3607_ _4516_/Q _4625_/Q _3627_/B vssd1 vssd1 vccd1 vccd1 _3607_/Y sky130_fd_sc_hd__a21oi_1
XANTENNA__3902__A2 _3946_/A1 vssd1 vssd1 vccd1 vccd1 sky130_fd_sc_hd__diode_2
X_3538_ _4580_/Q _3333_/B _3504_/A2 vssd1 vssd1 vccd1 vccd1 _3538_/X sky130_fd_sc_hd__a21bo_1
XANTENNA_clkbuf_leaf_51_clk_A clkload0/A vssd1 vssd1 vccd1 vccd1 sky130_fd_sc_hd__diode_2
XFILLER_67_28 vssd1 vssd1 vccd1 vccd1 sky130_fd_sc_hd__fill_1
X_3469_ _3469_/A _3469_/B vssd1 vssd1 vccd1 vccd1 _3469_/X sky130_fd_sc_hd__xor2_1
XFILLER_29_279 vssd1 vssd1 vccd1 vccd1 sky130_fd_sc_hd__fill_1
XFILLER_83_27 vccd1 vssd1 vccd1 vssd1 sky130_ef_sc_hd__decap_12
XANTENNA__3418__A1 _3423_/A1 vssd1 vssd1 vccd1 vccd1 sky130_fd_sc_hd__diode_2
XFILLER_44_216 vssd1 vssd1 vccd1 vccd1 sky130_fd_sc_hd__fill_2
XTAP_TAPCELL_ROW_27_436 vssd1 vccd1 sky130_fd_sc_hd__tapvpwrvgnd_1
XANTENNA__3969__A2 _3873_/Y vssd1 vssd1 vccd1 vccd1 sky130_fd_sc_hd__diode_2
XANTENNA__4437__RESET_B fanout435/X vssd1 vssd1 vccd1 vccd1 sky130_fd_sc_hd__diode_2
XANTENNA__2929__B1 _2930_/A2 vssd1 vssd1 vccd1 vccd1 sky130_fd_sc_hd__diode_2
XFILLER_8_128 vssd1 vssd1 vccd1 vccd1 sky130_fd_sc_hd__fill_1
XANTENNA_clkbuf_leaf_19_clk_A clkbuf_2_3__f_clk/X vssd1 vssd1 vccd1 vccd1 sky130_fd_sc_hd__diode_2
XANTENNA__4815__Q _4815_/Q vssd1 vssd1 vccd1 vccd1 sky130_fd_sc_hd__diode_2
XFILLER_75_374 vssd1 vssd1 vccd1 vccd1 sky130_fd_sc_hd__fill_1
XTAP_TAPCELL_ROW_61_737 vssd1 vccd1 sky130_fd_sc_hd__tapvpwrvgnd_1
XANTENNA__4253__S _4253_/S vssd1 vssd1 vccd1 vccd1 sky130_fd_sc_hd__diode_2
X_2840_ _2840_/A _2840_/B _2840_/C vssd1 vssd1 vccd1 vccd1 _2842_/A sky130_fd_sc_hd__and3_1
X_2771_ _2771_/A _2771_/B _2771_/C vssd1 vssd1 vccd1 vccd1 _2775_/A sky130_fd_sc_hd__nor3_1
X_4510_ _4669_/CLK _4510_/D fanout408/X vssd1 vssd1 vccd1 vccd1 _4510_/Q sky130_fd_sc_hd__dfrtp_2
X_4441_ _4575_/CLK _4441_/D fanout436/X vssd1 vssd1 vccd1 vccd1 hold60/A sky130_fd_sc_hd__dfrtp_1
Xhold117 _4654_/Q vssd1 vssd1 vccd1 vccd1 hold117/X sky130_fd_sc_hd__dlygate4sd3_1
XANTENNA__4137__A2 _4173_/A2 vssd1 vssd1 vccd1 vccd1 sky130_fd_sc_hd__diode_2
Xhold106 _4772_/Q vssd1 vssd1 vccd1 vccd1 hold106/X sky130_fd_sc_hd__dlygate4sd3_1
XPHY_EDGE_ROW_9_Right_9 vssd1 vssd1 vccd1 vccd1 sky130_fd_sc_hd__decap_3
Xhold139 _4659_/Q vssd1 vssd1 vccd1 vccd1 hold139/X sky130_fd_sc_hd__dlygate4sd3_1
Xhold128 _4682_/Q vssd1 vssd1 vccd1 vccd1 hold128/X sky130_fd_sc_hd__dlygate4sd3_1
X_4372_ _4372_/A _4372_/B vssd1 vssd1 vccd1 vccd1 _4372_/Y sky130_fd_sc_hd__nor2_1
X_3323_ _3528_/B _3323_/B vssd1 vssd1 vccd1 vccd1 _3535_/A sky130_fd_sc_hd__nand2_1
XANTENNA__4001__B _4001_/B vssd1 vssd1 vccd1 vccd1 sky130_fd_sc_hd__diode_2
X_3254_ _3251_/Y _3227_/Y _3252_/Y vssd1 vssd1 vccd1 vccd1 _3254_/X sky130_fd_sc_hd__a21o_1
X_2205_ _4001_/C vssd1 vssd1 vccd1 vccd1 _2205_/Y sky130_fd_sc_hd__inv_2
X_3185_ _4568_/Q _4609_/Q _3184_/X vssd1 vssd1 vccd1 vccd1 _3185_/Y sky130_fd_sc_hd__a21oi_1
XFILLER_66_363 vssd1 vssd1 vccd1 vccd1 sky130_fd_sc_hd__fill_1
XTAP_TAPCELL_ROW_77_881 vssd1 vccd1 sky130_fd_sc_hd__tapvpwrvgnd_1
XANTENNA__4073__A1 _4274_/D vssd1 vssd1 vccd1 vccd1 sky130_fd_sc_hd__diode_2
XTAP_TAPCELL_ROW_24_406 vssd1 vccd1 sky130_fd_sc_hd__tapvpwrvgnd_1
XFILLER_41_219 vssd1 vssd1 vccd1 vccd1 sky130_fd_sc_hd__fill_1
XANTENNA__4203__A_N _4258_/C vssd1 vssd1 vccd1 vccd1 sky130_fd_sc_hd__diode_2
XFILLER_22_433 vssd1 vssd1 vccd1 vccd1 sky130_fd_sc_hd__fill_1
XANTENNA_fanout332_A _4332_/A vssd1 vssd1 vccd1 vccd1 sky130_fd_sc_hd__diode_2
XANTENNA__4376__A2 _4376_/A2 vssd1 vssd1 vccd1 vccd1 sky130_fd_sc_hd__diode_2
X_2969_ _2969_/A _2969_/B vssd1 vssd1 vccd1 vccd1 _2971_/B sky130_fd_sc_hd__or2_1
XFILLER_5_109 vssd1 vssd1 vccd1 vccd1 sky130_fd_sc_hd__decap_3
X_4708_ clkload6/A _4708_/D fanout380/X vssd1 vssd1 vccd1 vccd1 _4708_/Q sky130_fd_sc_hd__dfrtp_1
XANTENNA_fanout218_X _3543_/A vssd1 vssd1 vccd1 vccd1 sky130_fd_sc_hd__diode_2
XANTENNA__2411__S _2421_/S vssd1 vssd1 vccd1 vccd1 sky130_fd_sc_hd__diode_2
X_4639_ _4640_/CLK _4639_/D fanout427/X vssd1 vssd1 vccd1 vccd1 _4639_/Q sky130_fd_sc_hd__dfrtp_1
XFILLER_76_127 vssd1 vssd1 vccd1 vccd1 sky130_fd_sc_hd__decap_3
XFILLER_72_322 vssd1 vssd1 vccd1 vccd1 sky130_fd_sc_hd__decap_4
XFILLER_57_374 vccd1 vssd1 vccd1 vssd1 sky130_ef_sc_hd__decap_12
XFILLER_4_131 vssd1 vssd1 vccd1 vccd1 sky130_fd_sc_hd__fill_2
XFILLER_4_197 vssd1 vssd1 vccd1 vccd1 sky130_fd_sc_hd__decap_6
XFILLER_67_127 vssd1 vssd1 vccd1 vccd1 sky130_fd_sc_hd__fill_1
XANTENNA__2302__A1 _2310_/A1 vssd1 vssd1 vccd1 vccd1 sky130_fd_sc_hd__diode_2
XTAP_TAPCELL_ROW_74_851 vssd1 vccd1 sky130_fd_sc_hd__tapvpwrvgnd_1
XANTENNA__4055__A1 _4083_/A1 vssd1 vssd1 vccd1 vccd1 sky130_fd_sc_hd__diode_2
X_3941_ _3872_/X _3971_/A1 _4063_/S vssd1 vssd1 vccd1 vccd1 _3941_/X sky130_fd_sc_hd__mux2_1
XFILLER_16_282 vssd1 vssd1 vccd1 vccd1 sky130_fd_sc_hd__fill_1
X_3872_ _3873_/A _4804_/Q vssd1 vssd1 vccd1 vccd1 _3872_/X sky130_fd_sc_hd__and2_2
XFILLER_31_252 vssd1 vssd1 vccd1 vccd1 sky130_fd_sc_hd__decap_4
XFILLER_31_263 vssd1 vssd1 vccd1 vccd1 sky130_fd_sc_hd__decap_8
X_2823_ _2823_/A _2823_/B vssd1 vssd1 vccd1 vccd1 _2823_/Y sky130_fd_sc_hd__nor2_1
X_2754_ _2754_/A _2754_/B _2754_/C vssd1 vssd1 vccd1 vccd1 _2754_/X sky130_fd_sc_hd__and3_1
X_2685_ _2724_/A _2685_/B vssd1 vssd1 vccd1 vccd1 _2688_/C sky130_fd_sc_hd__nand2_1
X_4424_ _4553_/CLK _4424_/D fanout419/X vssd1 vssd1 vccd1 vccd1 hold51/A sky130_fd_sc_hd__dfrtp_1
X_4355_ _4374_/A0 _4374_/A1 _4360_/A vssd1 vssd1 vccd1 vccd1 _4355_/X sky130_fd_sc_hd__mux2_1
Xfanout405 input2/X vssd1 vssd1 vccd1 vccd1 fanout405/X sky130_fd_sc_hd__buf_2
Xfanout438 fanout439/X vssd1 vssd1 vccd1 vccd1 fanout438/X sky130_fd_sc_hd__buf_2
X_3306_ _3524_/A vssd1 vssd1 vccd1 vccd1 _3313_/B sky130_fd_sc_hd__inv_2
Xfanout416 fanout424/X vssd1 vssd1 vccd1 vccd1 fanout416/X sky130_fd_sc_hd__clkbuf_2
Xfanout427 fanout440/X vssd1 vssd1 vccd1 vccd1 fanout427/X sky130_fd_sc_hd__buf_2
X_4286_ _4286_/A_N _4306_/B _4302_/C _4352_/A vssd1 vssd1 vccd1 vccd1 _4286_/X sky130_fd_sc_hd__and4b_1
XANTENNA_fanout282_A _4810_/Q vssd1 vssd1 vccd1 vccd1 sky130_fd_sc_hd__diode_2
X_3237_ _4551_/Q _4592_/Q vssd1 vssd1 vccd1 vccd1 _3241_/A sky130_fd_sc_hd__and2_1
X_3168_ _3168_/A _3168_/B vssd1 vssd1 vccd1 vccd1 _3187_/A sky130_fd_sc_hd__nor2_1
XTAP_TAPCELL_ROW_37_520 vssd1 vccd1 sky130_fd_sc_hd__tapvpwrvgnd_1
XFILLER_54_355 vssd1 vssd1 vccd1 vccd1 sky130_fd_sc_hd__fill_1
X_3099_ _3862_/A _3862_/B _3130_/B _3098_/B vssd1 vssd1 vccd1 vccd1 _3101_/B sky130_fd_sc_hd__o2bb2a_1
XFILLER_81_152 vssd1 vssd1 vccd1 vccd1 sky130_fd_sc_hd__fill_1
XANTENNA_fanout168_X _4167_/A1 vssd1 vssd1 vccd1 vccd1 sky130_fd_sc_hd__diode_2
XFILLER_54_377 vssd1 vssd1 vccd1 vccd1 sky130_fd_sc_hd__fill_2
XANTENNA__2406__S _2420_/S vssd1 vssd1 vccd1 vccd1 sky130_fd_sc_hd__diode_2
Xfanout89 _4402_/S vssd1 vssd1 vccd1 vccd1 _4400_/S sky130_fd_sc_hd__clkbuf_4
XFILLER_13_55 vssd1 vssd1 vccd1 vccd1 sky130_fd_sc_hd__fill_1
XFILLER_22_296 vssd1 vssd1 vccd1 vccd1 sky130_fd_sc_hd__decap_8
XTAP_TAPCELL_ROW_9_267 vssd1 vccd1 sky130_fd_sc_hd__tapvpwrvgnd_1
XFILLER_38_96 vssd1 vssd1 vccd1 vccd1 sky130_fd_sc_hd__fill_1
XANTENNA_input10_A s_axis_tdata[16] vssd1 vssd1 vccd1 vccd1 sky130_fd_sc_hd__diode_2
XTAP_TAPCELL_ROW_71_832 vssd1 vccd1 sky130_fd_sc_hd__tapvpwrvgnd_1
XFILLER_45_399 vssd1 vssd1 vccd1 vccd1 sky130_fd_sc_hd__decap_4
XTAP_TAPCELL_ROW_43_578 vssd1 vccd1 sky130_fd_sc_hd__tapvpwrvgnd_1
Xclkload26 _4780_/CLK vssd1 vssd1 vccd1 vccd1 clkload26/Y sky130_fd_sc_hd__inv_6
XFILLER_9_289 vssd1 vssd1 vccd1 vccd1 sky130_fd_sc_hd__decap_3
XPHY_EDGE_ROW_41_Left_129 vssd1 vssd1 vccd1 vccd1 sky130_fd_sc_hd__decap_3
Xclkload15 _4774_/CLK vssd1 vssd1 vccd1 vccd1 clkload15/Y sky130_fd_sc_hd__bufinv_16
Xclkload37 _4631_/CLK vssd1 vssd1 vccd1 vccd1 clkload37/Y sky130_fd_sc_hd__clkinv_2
Xclkload48 _4562_/CLK vssd1 vssd1 vccd1 vccd1 clkload48/Y sky130_fd_sc_hd__clkinvlp_4
X_2470_ _4455_/Q _4660_/Q _2470_/C vssd1 vssd1 vccd1 vccd1 _2489_/A sky130_fd_sc_hd__and3_1
XFILLER_79_81 vccd1 vssd1 vccd1 vssd1 sky130_ef_sc_hd__decap_12
XFILLER_5_484 vccd1 vssd1 vccd1 vssd1 sky130_ef_sc_hd__decap_12
X_4140_ _4140_/A_N _4812_/Q _4148_/C _4274_/D vssd1 vssd1 vccd1 vccd1 _4140_/X sky130_fd_sc_hd__and4b_1
XANTENNA__2287__A _4120_/D vssd1 vssd1 vccd1 vccd1 sky130_fd_sc_hd__diode_2
X_4071_ _4103_/A0 _4103_/A1 _4071_/S vssd1 vssd1 vccd1 vccd1 _4071_/X sky130_fd_sc_hd__mux2_1
XPHY_EDGE_ROW_50_Left_138 vssd1 vssd1 vccd1 vccd1 sky130_fd_sc_hd__decap_3
X_3022_ _3049_/B _4752_/Q vssd1 vssd1 vccd1 vccd1 _3024_/A sky130_fd_sc_hd__and2_1
XFILLER_36_333 vssd1 vssd1 vccd1 vccd1 sky130_fd_sc_hd__decap_6
X_3924_ _4581_/Q _2274_/B _2369_/S _4411_/S vssd1 vssd1 vccd1 vccd1 _4667_/D sky130_fd_sc_hd__a31o_1
X_3855_ _3147_/X _3155_/X _3156_/Y vssd1 vssd1 vccd1 vccd1 _3855_/Y sky130_fd_sc_hd__a21oi_1
Xclkload9 clkload9/A vssd1 vssd1 vccd1 vccd1 clkload9/Y sky130_fd_sc_hd__inv_6
X_3786_ _4538_/Q _4647_/Q vssd1 vssd1 vccd1 vccd1 _3786_/X sky130_fd_sc_hd__and2_1
XANTENNA__4200__A1 _4266_/D vssd1 vssd1 vccd1 vccd1 sky130_fd_sc_hd__diode_2
XANTENNA_fanout128_A _4376_/A2 vssd1 vssd1 vccd1 vccd1 sky130_fd_sc_hd__diode_2
X_2806_ _2806_/A _2806_/B _2806_/C vssd1 vssd1 vccd1 vccd1 _2812_/A sky130_fd_sc_hd__and3_1
X_2737_ _2735_/Y _2736_/X _2785_/A _2730_/X vssd1 vssd1 vccd1 vccd1 _2737_/X sky130_fd_sc_hd__o211a_1
X_2668_ _2716_/B _2668_/B _2716_/D _2668_/D vssd1 vssd1 vccd1 vccd1 _2669_/B sky130_fd_sc_hd__nand4_1
X_4407_ _4306_/B input23/X _4408_/S vssd1 vssd1 vccd1 vccd1 _4816_/D sky130_fd_sc_hd__mux2_1
Xfanout202 _2282_/X vssd1 vssd1 vccd1 vccd1 _2323_/B sky130_fd_sc_hd__buf_2
X_2599_ _2599_/A _2599_/B _2599_/C vssd1 vssd1 vccd1 vccd1 _2601_/A sky130_fd_sc_hd__or3_1
Xfanout213 fanout215/X vssd1 vssd1 vccd1 vccd1 _3613_/C sky130_fd_sc_hd__buf_2
XFILLER_86_211 vccd1 vssd1 vccd1 vssd1 sky130_ef_sc_hd__decap_12
Xfanout246 _2419_/S vssd1 vssd1 vccd1 vccd1 _2421_/S sky130_fd_sc_hd__clkbuf_4
X_4338_ hold192/X _4338_/A2 _4335_/X _4337_/X vssd1 vssd1 vccd1 vccd1 _4777_/D sky130_fd_sc_hd__o22a_1
Xfanout235 _2275_/X vssd1 vssd1 vccd1 vccd1 _2335_/B sky130_fd_sc_hd__buf_2
Xfanout224 _3913_/X vssd1 vssd1 vccd1 vccd1 _4212_/A2 sky130_fd_sc_hd__buf_2
Xfanout257 _4816_/Q vssd1 vssd1 vccd1 vccd1 _4306_/B sky130_fd_sc_hd__clkbuf_2
XANTENNA_fanout285_X _3976_/D vssd1 vssd1 vccd1 vccd1 sky130_fd_sc_hd__diode_2
XANTENNA_input2_A rst_n vssd1 vssd1 vccd1 vccd1 sky130_fd_sc_hd__diode_2
Xfanout268 _4813_/Q vssd1 vssd1 vccd1 vccd1 _4140_/A_N sky130_fd_sc_hd__buf_1
XANTENNA__4267__A1 _4266_/D vssd1 vssd1 vccd1 vccd1 sky130_fd_sc_hd__diode_2
Xfanout279 _4148_/C vssd1 vssd1 vccd1 vccd1 _4175_/C sky130_fd_sc_hd__dlymetal6s2s_1
X_4269_ _4281_/A0 _4281_/A1 _4274_/D vssd1 vssd1 vccd1 vccd1 _4269_/X sky130_fd_sc_hd__mux2_1
XFILLER_86_299 vssd1 vssd1 vccd1 vccd1 sky130_fd_sc_hd__decap_8
XFILLER_74_428 vssd1 vssd1 vccd1 vccd1 sky130_fd_sc_hd__decap_8
XTAP_TAPCELL_ROW_85_957 vssd1 vccd1 sky130_fd_sc_hd__tapvpwrvgnd_1
XFILLER_67_480 vssd1 vssd1 vccd1 vccd1 sky130_fd_sc_hd__fill_2
XFILLER_27_333 vssd1 vssd1 vccd1 vccd1 sky130_fd_sc_hd__decap_3
XANTENNA__3490__A2 _3522_/A2 vssd1 vssd1 vccd1 vccd1 sky130_fd_sc_hd__diode_2
XFILLER_54_174 vssd1 vssd1 vccd1 vccd1 sky130_fd_sc_hd__decap_4
XANTENNA__3793__A3 _2369_/S vssd1 vssd1 vccd1 vccd1 sky130_fd_sc_hd__diode_2
XTAP_TAPCELL_ROW_40_548 vssd1 vccd1 sky130_fd_sc_hd__tapvpwrvgnd_1
XFILLER_10_266 vccd1 vssd1 vccd1 vssd1 sky130_ef_sc_hd__decap_12
XFILLER_6_248 vssd1 vssd1 vccd1 vccd1 sky130_fd_sc_hd__decap_4
XANTENNA__3950__B1 _4071_/S vssd1 vssd1 vccd1 vccd1 sky130_fd_sc_hd__diode_2
XFILLER_40_97 vccd1 vssd1 vccd1 vssd1 sky130_ef_sc_hd__decap_12
XFILLER_2_432 vssd1 vssd1 vccd1 vccd1 sky130_fd_sc_hd__decap_3
XFILLER_77_255 vssd1 vssd1 vccd1 vccd1 sky130_fd_sc_hd__fill_1
XFILLER_49_95 vssd1 vssd1 vccd1 vccd1 sky130_fd_sc_hd__fill_2
XFILLER_65_417 vssd1 vssd1 vccd1 vccd1 sky130_fd_sc_hd__decap_8
XFILLER_73_494 vssd1 vssd1 vccd1 vccd1 sky130_fd_sc_hd__decap_4
XFILLER_45_196 vccd1 vssd1 vccd1 vssd1 sky130_ef_sc_hd__decap_12
XTAP_TAPCELL_ROW_56_692 vssd1 vccd1 sky130_fd_sc_hd__tapvpwrvgnd_1
X_3640_ _3638_/X _3549_/A _3637_/Y _3639_/X vssd1 vssd1 vccd1 vccd1 _4595_/D sky130_fd_sc_hd__a31o_1
XANTENNA__4261__S _4266_/D vssd1 vssd1 vccd1 vccd1 sky130_fd_sc_hd__diode_2
X_3571_ _4512_/Q _4621_/Q vssd1 vssd1 vccd1 vccd1 _3571_/Y sky130_fd_sc_hd__nand2_1
XANTENNA__4194__A0 _4214_/A0 vssd1 vssd1 vccd1 vccd1 sky130_fd_sc_hd__diode_2
XANTENNA__3941__A0 _3872_/X vssd1 vssd1 vccd1 vccd1 sky130_fd_sc_hd__diode_2
X_2522_ _2522_/A _2522_/B _2522_/C _2522_/D vssd1 vssd1 vccd1 vccd1 _2523_/B sky130_fd_sc_hd__or4_1
XFILLER_53_3 vssd1 vssd1 vccd1 vccd1 sky130_fd_sc_hd__decap_4
XFILLER_5_281 vccd1 vssd1 vccd1 vssd1 sky130_ef_sc_hd__decap_12
X_2453_ _2473_/A _2453_/B vssd1 vssd1 vccd1 vccd1 _2453_/Y sky130_fd_sc_hd__nand2_1
X_2384_ hold5/X _2383_/X _2426_/S vssd1 vssd1 vccd1 vccd1 _4487_/D sky130_fd_sc_hd__mux2_1
X_4123_ _4167_/A0 _4171_/A1 _4123_/S vssd1 vssd1 vccd1 vccd1 _4123_/X sky130_fd_sc_hd__mux2_1
XFILLER_68_277 vssd1 vssd1 vccd1 vccd1 sky130_fd_sc_hd__decap_4
Xinput2 rst_n vssd1 vssd1 vccd1 vccd1 input2/X sky130_fd_sc_hd__clkbuf_2
XTAP_TAPCELL_ROW_3_218 vssd1 vccd1 sky130_fd_sc_hd__tapvpwrvgnd_1
X_4054_ _4053_/Y _4052_/X _4051_/X _4705_/Q _4122_/B1 vssd1 vssd1 vccd1 vccd1 _4705_/D
+ sky130_fd_sc_hd__o32a_1
XFILLER_83_225 vssd1 vssd1 vccd1 vccd1 sky130_fd_sc_hd__fill_2
X_3005_ _3033_/A _3005_/B vssd1 vssd1 vccd1 vccd1 _3007_/C sky130_fd_sc_hd__nand2_1
XFILLER_49_491 vssd1 vssd1 vccd1 vccd1 sky130_fd_sc_hd__fill_1
XTAP_TAPCELL_ROW_82_927 vssd1 vccd1 sky130_fd_sc_hd__tapvpwrvgnd_1
XFILLER_36_130 vssd1 vssd1 vccd1 vccd1 sky130_fd_sc_hd__decap_8
XFILLER_36_141 vssd1 vssd1 vccd1 vccd1 sky130_fd_sc_hd__decap_4
XTAP_TAPCELL_ROW_19_361 vssd1 vccd1 sky130_fd_sc_hd__tapvpwrvgnd_1
XANTENNA_fanout245_A _2419_/S vssd1 vssd1 vccd1 vccd1 sky130_fd_sc_hd__diode_2
X_3907_ _4068_/B _4056_/D _4116_/D vssd1 vssd1 vccd1 vccd1 _3907_/X sky130_fd_sc_hd__or3b_1
XANTENNA__4171__S _4803_/Q vssd1 vssd1 vccd1 vccd1 sky130_fd_sc_hd__diode_2
X_3838_ hold204/X _3848_/A2 _3837_/Y vssd1 vssd1 vccd1 vccd1 _4637_/D sky130_fd_sc_hd__a21o_1
X_3769_ _3767_/X _3768_/Y _3543_/B _3784_/A1 vssd1 vssd1 vccd1 vccd1 _3769_/X sky130_fd_sc_hd__o211a_1
XANTENNA_fanout200_X _2420_/S vssd1 vssd1 vccd1 vccd1 sky130_fd_sc_hd__diode_2
XANTENNA__3932__A0 _3872_/X vssd1 vssd1 vccd1 vccd1 sky130_fd_sc_hd__diode_2
XFILLER_86_27 vssd1 vssd1 vccd1 vccd1 sky130_fd_sc_hd__fill_1
XFILLER_47_417 vccd1 vssd1 vccd1 vssd1 sky130_ef_sc_hd__decap_12
XFILLER_59_266 vccd1 vssd1 vccd1 vssd1 sky130_ef_sc_hd__decap_12
XFILLER_19_87 vssd1 vssd1 vccd1 vccd1 sky130_fd_sc_hd__decap_3
XTAP_TAPCELL_ROW_53_662 vssd1 vccd1 sky130_fd_sc_hd__tapvpwrvgnd_1
XFILLER_76_60 vssd1 vssd1 vccd1 vccd1 sky130_fd_sc_hd__fill_2
XFILLER_65_214 vssd1 vssd1 vccd1 vccd1 sky130_fd_sc_hd__decap_8
XFILLER_65_225 vccd1 vssd1 vccd1 vssd1 sky130_ef_sc_hd__decap_12
XANTENNA__3439__C1 _3923_/A vssd1 vssd1 vccd1 vccd1 sky130_fd_sc_hd__diode_2
XFILLER_33_100 vssd1 vssd1 vccd1 vccd1 sky130_fd_sc_hd__fill_1
X_4810_ clkload3/A _4810_/D fanout376/X vssd1 vssd1 vccd1 vccd1 _4810_/Q sky130_fd_sc_hd__dfrtp_1
XTAP_TAPCELL_ROW_16_331 vssd1 vccd1 sky130_fd_sc_hd__tapvpwrvgnd_1
X_4741_ _4744_/CLK _4741_/D fanout391/X vssd1 vssd1 vccd1 vccd1 _4741_/Q sky130_fd_sc_hd__dfrtp_1
X_4672_ _4687_/CLK _4672_/D fanout383/X vssd1 vssd1 vccd1 vccd1 _4672_/Q sky130_fd_sc_hd__dfrtp_1
XANTENNA__4167__A0 _4167_/A0 vssd1 vssd1 vccd1 vccd1 sky130_fd_sc_hd__diode_2
X_3623_ _4518_/Q _4627_/Q _4517_/Q _4626_/Q vssd1 vssd1 vccd1 vccd1 _3623_/X sky130_fd_sc_hd__a211o_1
X_3554_ _3551_/X _3553_/Y _3558_/A vssd1 vssd1 vccd1 vccd1 _3555_/A sky130_fd_sc_hd__o21ai_1
X_3485_ _3301_/X _3463_/A _3188_/B vssd1 vssd1 vccd1 vccd1 _3487_/A sky130_fd_sc_hd__o21ai_2
X_2505_ _2505_/A _2505_/B vssd1 vssd1 vccd1 vccd1 _2533_/A sky130_fd_sc_hd__nand2_1
X_2436_ _4672_/Q _4453_/Q vssd1 vssd1 vccd1 vccd1 _2438_/A sky130_fd_sc_hd__and2_1
XFILLER_84_501 vccd1 vssd1 vccd1 vssd1 sky130_ef_sc_hd__decap_12
X_2367_ _4551_/Q hold27/A _2369_/S vssd1 vssd1 vccd1 vccd1 _2367_/X sky130_fd_sc_hd__mux2_1
XFILLER_29_417 vssd1 vssd1 vccd1 vccd1 sky130_fd_sc_hd__fill_2
X_2298_ _3875_/A0 _2310_/A1 _4063_/S vssd1 vssd1 vccd1 vccd1 _2298_/X sky130_fd_sc_hd__mux2_1
X_4106_ _4105_/Y _4104_/X _4103_/X hold176/X _4225_/B2 vssd1 vssd1 vccd1 vccd1 _4718_/D
+ sky130_fd_sc_hd__o32a_1
XFILLER_56_236 vssd1 vssd1 vccd1 vccd1 sky130_fd_sc_hd__decap_4
X_4037_ _3976_/D _4037_/B _4037_/C _4037_/D vssd1 vssd1 vccd1 vccd1 _4037_/X sky130_fd_sc_hd__and4b_1
XTAP_TAPCELL_ROW_50_643 vssd1 vccd1 sky130_fd_sc_hd__tapvpwrvgnd_1
XANTENNA__2414__S _2420_/S vssd1 vssd1 vccd1 vccd1 sky130_fd_sc_hd__diode_2
XTAP_TAPCELL_ROW_22_389 vssd1 vccd1 sky130_fd_sc_hd__tapvpwrvgnd_1
XFILLER_21_44 vccd1 vssd1 vccd1 vssd1 sky130_ef_sc_hd__decap_12
XFILLER_87_361 vssd1 vssd1 vccd1 vccd1 sky130_fd_sc_hd__decap_3
XTAP_TAPCELL_ROW_58_710 vssd1 vccd1 sky130_fd_sc_hd__tapvpwrvgnd_1
XFILLER_28_472 vssd1 vssd1 vccd1 vccd1 sky130_fd_sc_hd__decap_4
XFILLER_46_85 vssd1 vssd1 vccd1 vccd1 sky130_fd_sc_hd__decap_3
XFILLER_55_291 vssd1 vssd1 vccd1 vccd1 sky130_fd_sc_hd__decap_3
XFILLER_70_250 vssd1 vssd1 vccd1 vccd1 sky130_fd_sc_hd__fill_2
XFILLER_30_103 vssd1 vssd1 vccd1 vccd1 sky130_fd_sc_hd__decap_3
XFILLER_30_114 vssd1 vssd1 vccd1 vccd1 sky130_fd_sc_hd__decap_6
XFILLER_7_310 vssd1 vssd1 vccd1 vccd1 sky130_fd_sc_hd__decap_3
XANTENNA__3977__A_N _3976_/D vssd1 vssd1 vccd1 vccd1 sky130_fd_sc_hd__diode_2
XFILLER_7_57 vccd1 vssd1 vccd1 vssd1 sky130_ef_sc_hd__decap_12
X_3270_ _4546_/Q _4587_/Q vssd1 vssd1 vccd1 vccd1 _3359_/B sky130_fd_sc_hd__nand2_1
X_2221_ _4459_/Q vssd1 vssd1 vccd1 vccd1 _2516_/B sky130_fd_sc_hd__inv_2
XANTENNA__4321__B1 _4338_/A2 vssd1 vssd1 vccd1 vccd1 sky130_fd_sc_hd__diode_2
XFILLER_78_361 vssd1 vssd1 vccd1 vccd1 sky130_fd_sc_hd__decap_3
XFILLER_78_394 vccd1 vssd1 vccd1 vssd1 sky130_ef_sc_hd__decap_12
XFILLER_19_461 vssd1 vssd1 vccd1 vccd1 sky130_fd_sc_hd__decap_4
XTAP_TAPCELL_ROW_64_768 vssd1 vccd1 sky130_fd_sc_hd__tapvpwrvgnd_1
XANTENNA__4388__A0 _4219_/C vssd1 vssd1 vccd1 vccd1 sky130_fd_sc_hd__diode_2
X_2985_ hold189/X _2985_/A2 _2970_/Y _2984_/Y vssd1 vssd1 vccd1 vccd1 _4531_/D sky130_fd_sc_hd__o22a_1
XFILLER_21_147 vccd1 vssd1 vccd1 vssd1 sky130_ef_sc_hd__decap_12
XFILLER_21_169 vssd1 vssd1 vccd1 vccd1 sky130_fd_sc_hd__fill_1
X_4724_ clkload6/A _4724_/D fanout380/X vssd1 vssd1 vccd1 vccd1 hold90/A sky130_fd_sc_hd__dfrtp_1
X_4655_ clkload6/A _4655_/D fanout380/X vssd1 vssd1 vccd1 vccd1 _4655_/Q sky130_fd_sc_hd__dfrtp_1
X_4586_ _4587_/CLK _4586_/D fanout408/X vssd1 vssd1 vccd1 vccd1 _4586_/Q sky130_fd_sc_hd__dfrtp_2
XANTENNA_fanout208_A _3946_/A2 vssd1 vssd1 vccd1 vccd1 sky130_fd_sc_hd__diode_2
X_3606_ _4516_/Q _4625_/Q _4515_/Q _4624_/Q vssd1 vssd1 vccd1 vccd1 _3627_/B sky130_fd_sc_hd__o211a_1
XANTENNA_fanout110_A _3828_/A2 vssd1 vssd1 vccd1 vccd1 sky130_fd_sc_hd__diode_2
X_3537_ _3536_/Y _3504_/Y _3540_/B2 _4579_/Q vssd1 vssd1 vccd1 vccd1 _4579_/D sky130_fd_sc_hd__a2bb2o_1
X_3468_ _4565_/Q _4606_/Q _3464_/X vssd1 vssd1 vccd1 vccd1 _3469_/B sky130_fd_sc_hd__a21boi_1
X_2419_ _4577_/Q hold40/A _2419_/S vssd1 vssd1 vccd1 vccd1 _2419_/X sky130_fd_sc_hd__mux2_1
X_3399_ _3423_/A1 _3398_/X _3423_/B1 vssd1 vssd1 vccd1 vccd1 _3399_/X sky130_fd_sc_hd__a21o_1
XANTENNA__2409__S _2421_/S vssd1 vssd1 vccd1 vccd1 sky130_fd_sc_hd__diode_2
XFILLER_29_269 vssd1 vssd1 vccd1 vccd1 sky130_fd_sc_hd__decap_4
XFILLER_83_39 vccd1 vssd1 vccd1 vssd1 sky130_ef_sc_hd__decap_12
XFILLER_25_420 vssd1 vssd1 vccd1 vccd1 sky130_fd_sc_hd__decap_4
XFILLER_32_65 vssd1 vssd1 vccd1 vccd1 sky130_fd_sc_hd__fill_1
XANTENNA__3409__A2 _3425_/A2 vssd1 vssd1 vccd1 vccd1 sky130_fd_sc_hd__diode_2
XANTENNA__4005__A_N _4064_/C vssd1 vssd1 vccd1 vccd1 sky130_fd_sc_hd__diode_2
XFILLER_43_261 vssd1 vssd1 vccd1 vccd1 sky130_fd_sc_hd__decap_4
XTAP_TAPCELL_ROW_61_738 vssd1 vccd1 sky130_fd_sc_hd__tapvpwrvgnd_1
X_2770_ _2770_/A _4699_/Q vssd1 vssd1 vccd1 vccd1 _2771_/A sky130_fd_sc_hd__nor2_1
X_4440_ _4612_/CLK _4440_/D fanout436/X vssd1 vssd1 vccd1 vccd1 hold42/A sky130_fd_sc_hd__dfrtp_1
Xhold107 _4453_/Q vssd1 vssd1 vccd1 vccd1 hold107/X sky130_fd_sc_hd__dlygate4sd3_1
Xhold129 _4641_/Q vssd1 vssd1 vccd1 vccd1 hold129/X sky130_fd_sc_hd__dlygate4sd3_1
Xhold118 _4728_/Q vssd1 vssd1 vccd1 vccd1 hold118/X sky130_fd_sc_hd__dlygate4sd3_1
X_4371_ _4371_/A _4371_/B _4371_/C vssd1 vssd1 vccd1 vccd1 _4371_/X sky130_fd_sc_hd__and3_1
X_3322_ _3528_/A _3322_/B vssd1 vssd1 vccd1 vccd1 _3323_/B sky130_fd_sc_hd__and2_1
XANTENNA__4001__C _4001_/C vssd1 vssd1 vccd1 vccd1 sky130_fd_sc_hd__diode_2
X_3253_ _3251_/Y _3227_/Y _3252_/Y vssd1 vssd1 vccd1 vccd1 _3253_/Y sky130_fd_sc_hd__a21oi_1
X_3184_ _4568_/Q _4609_/Q _4608_/Q _4567_/Q vssd1 vssd1 vccd1 vccd1 _3184_/X sky130_fd_sc_hd__o211a_1
XANTENNA__2320__A2 _2323_/B vssd1 vssd1 vccd1 vccd1 sky130_fd_sc_hd__diode_2
XANTENNA__2856__B1 _2857_/A vssd1 vssd1 vccd1 vccd1 sky130_fd_sc_hd__diode_2
XTAP_TAPCELL_ROW_77_882 vssd1 vccd1 sky130_fd_sc_hd__tapvpwrvgnd_1
XANTENNA__4073__A2 _4105_/A2 vssd1 vssd1 vccd1 vccd1 sky130_fd_sc_hd__diode_2
XFILLER_22_401 vssd1 vssd1 vccd1 vccd1 sky130_fd_sc_hd__decap_4
XTAP_TAPCELL_ROW_24_407 vssd1 vccd1 sky130_fd_sc_hd__tapvpwrvgnd_1
XFILLER_34_250 vssd1 vssd1 vccd1 vccd1 sky130_fd_sc_hd__fill_2
XFILLER_34_261 vssd1 vssd1 vccd1 vccd1 sky130_fd_sc_hd__decap_4
XFILLER_34_272 vccd1 vssd1 vccd1 vssd1 sky130_ef_sc_hd__decap_12
XFILLER_34_294 vssd1 vssd1 vccd1 vccd1 sky130_fd_sc_hd__fill_2
X_2968_ _2960_/Y _2961_/X _2966_/Y vssd1 vssd1 vccd1 vccd1 _2969_/B sky130_fd_sc_hd__o21a_1
XTAP_TAPCELL_ROW_32_473 vssd1 vccd1 sky130_fd_sc_hd__tapvpwrvgnd_1
XANTENNA_fanout325_A _4794_/Q vssd1 vssd1 vccd1 vccd1 sky130_fd_sc_hd__diode_2
X_4707_ clkload6/A _4707_/D fanout380/X vssd1 vssd1 vccd1 vccd1 _4707_/Q sky130_fd_sc_hd__dfrtp_1
X_2899_ _2899_/A _2899_/B vssd1 vssd1 vccd1 vccd1 _3835_/B sky130_fd_sc_hd__nand2_1
X_4638_ _4640_/CLK _4638_/D fanout427/X vssd1 vssd1 vccd1 vccd1 _4638_/Q sky130_fd_sc_hd__dfrtp_1
XFILLER_78_39 vccd1 vssd1 vccd1 vssd1 sky130_ef_sc_hd__decap_12
X_4569_ _4575_/CLK _4569_/D fanout429/X vssd1 vssd1 vccd1 vccd1 _4569_/Q sky130_fd_sc_hd__dfrtp_4
XFILLER_57_331 vssd1 vssd1 vccd1 vccd1 sky130_fd_sc_hd__fill_2
XFILLER_57_386 vssd1 vssd1 vccd1 vccd1 sky130_fd_sc_hd__decap_6
XANTENNA__4178__A_N _4313_/S vssd1 vssd1 vccd1 vccd1 sky130_fd_sc_hd__diode_2
XFILLER_4_25 vssd1 vssd1 vccd1 vccd1 sky130_fd_sc_hd__fill_1
XFILLER_0_393 vssd1 vssd1 vccd1 vccd1 sky130_fd_sc_hd__fill_2
XFILLER_82_109 vssd1 vssd1 vccd1 vccd1 sky130_fd_sc_hd__fill_2
XTAP_TAPCELL_ROW_74_852 vssd1 vccd1 sky130_fd_sc_hd__tapvpwrvgnd_1
X_3940_ _3946_/A1 _3943_/A2 _3938_/X _3939_/X vssd1 vssd1 vccd1 vccd1 _4673_/D sky130_fd_sc_hd__a31o_1
XANTENNA_clkbuf_leaf_50_clk_A clkload0/A vssd1 vssd1 vccd1 vccd1 sky130_fd_sc_hd__diode_2
X_3871_ hold37/X hold57/A _3925_/S vssd1 vssd1 vccd1 vccd1 hold38/A sky130_fd_sc_hd__mux2_1
XFILLER_83_3 vccd1 vssd1 vccd1 vssd1 sky130_ef_sc_hd__decap_12
X_2822_ _2767_/C _2767_/Y _2819_/Y _2820_/X vssd1 vssd1 vccd1 vccd1 _2823_/B sky130_fd_sc_hd__a211oi_2
X_2753_ _2753_/A _2753_/B _2753_/C _2753_/D vssd1 vssd1 vccd1 vccd1 _2754_/C sky130_fd_sc_hd__nand4_1
X_2684_ _2681_/Y _2682_/X _2648_/C _2649_/B vssd1 vssd1 vccd1 vccd1 _2685_/B sky130_fd_sc_hd__o211ai_1
X_4423_ _4553_/CLK _4423_/D fanout419/X vssd1 vssd1 vccd1 vccd1 hold80/A sky130_fd_sc_hd__dfrtp_1
X_4354_ _4353_/Y _4352_/X _4351_/X _4781_/Q _4358_/A2 vssd1 vssd1 vccd1 vccd1 _4781_/D
+ sky130_fd_sc_hd__o32a_1
X_3305_ _4576_/Q _3308_/B vssd1 vssd1 vccd1 vccd1 _3524_/A sky130_fd_sc_hd__xnor2_1
Xfanout439 fanout440/X vssd1 vssd1 vccd1 vccd1 fanout439/X sky130_fd_sc_hd__clkbuf_2
Xfanout428 fanout430/X vssd1 vssd1 vccd1 vccd1 fanout428/X sky130_fd_sc_hd__clkbuf_4
Xfanout417 fanout418/X vssd1 vssd1 vccd1 vccd1 fanout417/X sky130_fd_sc_hd__buf_2
Xfanout406 fanout407/X vssd1 vssd1 vccd1 vccd1 fanout406/X sky130_fd_sc_hd__clkbuf_4
X_4285_ _4305_/A0 _4305_/A1 _4356_/A vssd1 vssd1 vccd1 vccd1 _4285_/X sky130_fd_sc_hd__mux2_1
XFILLER_58_139 vssd1 vssd1 vccd1 vccd1 sky130_fd_sc_hd__fill_1
X_3236_ _4552_/Q _4593_/Q vssd1 vssd1 vccd1 vccd1 _3393_/A sky130_fd_sc_hd__xor2_2
X_3167_ _4572_/Q _3308_/B vssd1 vssd1 vccd1 vccd1 _3168_/B sky130_fd_sc_hd__xnor2_1
XFILLER_66_161 vssd1 vssd1 vccd1 vccd1 sky130_fd_sc_hd__fill_1
X_3098_ _3130_/B _3098_/B _3144_/A vssd1 vssd1 vccd1 vccd1 _3101_/A sky130_fd_sc_hd__nor3_1
XTAP_TAPCELL_ROW_37_521 vssd1 vccd1 sky130_fd_sc_hd__tapvpwrvgnd_1
XFILLER_81_164 vssd1 vssd1 vccd1 vccd1 sky130_fd_sc_hd__decap_4
XFILLER_42_518 vssd1 vssd1 vccd1 vccd1 sky130_fd_sc_hd__fill_1
XANTENNA_clkbuf_leaf_18_clk_A clkload1/A vssd1 vssd1 vccd1 vccd1 sky130_fd_sc_hd__diode_2
XANTENNA_fanout230_X _4022_/A2 vssd1 vssd1 vccd1 vccd1 sky130_fd_sc_hd__diode_2
XFILLER_22_253 vssd1 vssd1 vccd1 vccd1 sky130_fd_sc_hd__decap_4
Xfanout79 _3423_/A1 vssd1 vssd1 vccd1 vccd1 _3383_/A1 sky130_fd_sc_hd__buf_2
XANTENNA_fanout328_X _4203_/C vssd1 vssd1 vccd1 vccd1 sky130_fd_sc_hd__diode_2
XANTENNA__2422__S _2424_/S vssd1 vssd1 vccd1 vccd1 sky130_fd_sc_hd__diode_2
XFILLER_13_67 vssd1 vssd1 vccd1 vccd1 sky130_fd_sc_hd__fill_2
XFILLER_1_113 vccd1 vssd1 vccd1 vssd1 sky130_ef_sc_hd__decap_12
XANTENNA_fanout90_A _4397_/S vssd1 vssd1 vccd1 vccd1 sky130_fd_sc_hd__diode_2
XTAP_TAPCELL_ROW_9_268 vssd1 vccd1 sky130_fd_sc_hd__tapvpwrvgnd_1
XFILLER_1_157 vssd1 vssd1 vccd1 vccd1 sky130_fd_sc_hd__fill_2
XFILLER_77_415 vccd1 vssd1 vccd1 vssd1 sky130_ef_sc_hd__decap_12
XFILLER_49_117 vssd1 vssd1 vccd1 vccd1 sky130_fd_sc_hd__decap_8
XANTENNA__2296__A1 _4123_/S vssd1 vssd1 vccd1 vccd1 sky130_fd_sc_hd__diode_2
XFILLER_45_356 vssd1 vssd1 vccd1 vccd1 sky130_fd_sc_hd__fill_1
XTAP_TAPCELL_ROW_0_190 vssd1 vccd1 sky130_fd_sc_hd__tapvpwrvgnd_1
XFILLER_54_85 vccd1 vssd1 vccd1 vssd1 sky130_ef_sc_hd__decap_12
XFILLER_13_275 vssd1 vssd1 vccd1 vccd1 sky130_fd_sc_hd__fill_1
XTAP_TAPCELL_ROW_43_579 vssd1 vccd1 sky130_fd_sc_hd__tapvpwrvgnd_1
XFILLER_13_286 vssd1 vssd1 vccd1 vccd1 sky130_fd_sc_hd__decap_3
XFILLER_70_73 vssd1 vssd1 vccd1 vccd1 sky130_fd_sc_hd__fill_1
Xclkload16 _4776_/CLK vssd1 vssd1 vccd1 vccd1 clkload16/X sky130_fd_sc_hd__clkbuf_4
Xclkload27 _4667_/CLK vssd1 vssd1 vccd1 vccd1 clkload27/Y sky130_fd_sc_hd__clkinv_2
Xclkload38 _4640_/CLK vssd1 vssd1 vccd1 vccd1 clkload38/Y sky130_fd_sc_hd__clkinvlp_4
Xclkload49 _4605_/CLK vssd1 vssd1 vccd1 vccd1 clkload49/Y sky130_fd_sc_hd__clkinv_4
XFILLER_55_7 vssd1 vssd1 vccd1 vccd1 sky130_fd_sc_hd__fill_1
XFILLER_5_496 vssd1 vssd1 vccd1 vccd1 sky130_fd_sc_hd__decap_8
XANTENNA__2508__C1 _3946_/A2 vssd1 vssd1 vccd1 vccd1 sky130_fd_sc_hd__diode_2
XTAP_TAPCELL_ROW_79_900 vssd1 vccd1 sky130_fd_sc_hd__tapvpwrvgnd_1
XFILLER_79_93 vssd1 vssd1 vccd1 vccd1 sky130_fd_sc_hd__decap_8
X_4070_ _4069_/Y _4068_/X _4067_/X hold108/X _4130_/B1 vssd1 vssd1 vccd1 vccd1 _4709_/D
+ sky130_fd_sc_hd__o32a_1
X_3021_ _3021_/A _3021_/B vssd1 vssd1 vccd1 vccd1 _3026_/A sky130_fd_sc_hd__nand2_1
X_3923_ _3923_/A _3923_/B _3923_/C vssd1 vssd1 vccd1 vccd1 _3923_/X sky130_fd_sc_hd__and3_1
X_3854_ _4645_/Q _3869_/S _3138_/A _3853_/Y vssd1 vssd1 vccd1 vccd1 _4645_/D sky130_fd_sc_hd__a22o_1
X_2805_ _4760_/Q _4775_/Q vssd1 vssd1 vccd1 vccd1 _2806_/C sky130_fd_sc_hd__xor2_1
X_3785_ _4538_/Q _4647_/Q vssd1 vssd1 vccd1 vccd1 _3785_/Y sky130_fd_sc_hd__nor2_1
XANTENNA__4200__A2 _4212_/A2 vssd1 vssd1 vccd1 vccd1 sky130_fd_sc_hd__diode_2
X_2736_ _2770_/A _4698_/Q _4466_/Q vssd1 vssd1 vccd1 vccd1 _2736_/X sky130_fd_sc_hd__and3_1
XANTENNA__2762__A2 _2797_/A2 vssd1 vssd1 vccd1 vccd1 sky130_fd_sc_hd__diode_2
X_2667_ _2716_/B _2668_/B _2716_/D _2668_/D vssd1 vssd1 vccd1 vccd1 _2669_/A sky130_fd_sc_hd__a22o_1
X_4406_ _4178_/D input22/X _4406_/S vssd1 vssd1 vccd1 vccd1 _4815_/D sky130_fd_sc_hd__mux2_1
Xfanout203 _2282_/X vssd1 vssd1 vccd1 vccd1 _2338_/B sky130_fd_sc_hd__clkbuf_2
X_2598_ _4739_/Q _4709_/Q vssd1 vssd1 vccd1 vccd1 _2599_/A sky130_fd_sc_hd__nor2_1
Xfanout214 fanout215/X vssd1 vssd1 vccd1 vccd1 _3925_/S sky130_fd_sc_hd__buf_2
XFILLER_86_223 vssd1 vssd1 vccd1 vccd1 sky130_fd_sc_hd__decap_8
Xfanout225 _3913_/X vssd1 vssd1 vccd1 vccd1 _4240_/A2 sky130_fd_sc_hd__clkbuf_2
Xfanout236 _2250_/S vssd1 vssd1 vccd1 vccd1 _2249_/S sky130_fd_sc_hd__clkbuf_4
Xfanout247 fanout248/X vssd1 vssd1 vccd1 vccd1 _2419_/S sky130_fd_sc_hd__buf_2
X_4337_ _4203_/C _4328_/C _4328_/B _4376_/A2 _4336_/Y vssd1 vssd1 vccd1 vccd1 _4337_/X
+ sky130_fd_sc_hd__a311o_1
Xfanout258 _4816_/Q vssd1 vssd1 vccd1 vccd1 _4282_/B sky130_fd_sc_hd__clkbuf_2
Xfanout269 _4231_/D vssd1 vssd1 vccd1 vccd1 _4223_/D sky130_fd_sc_hd__clkbuf_2
X_4268_ _4267_/Y _4266_/X _4265_/X hold213/X _4334_/A2 vssd1 vssd1 vccd1 vccd1 _4759_/D
+ sky130_fd_sc_hd__o32a_1
XANTENNA_fanout180_X _4214_/A0 vssd1 vssd1 vccd1 vccd1 sky130_fd_sc_hd__diode_2
X_3219_ _4556_/Q _4597_/Q vssd1 vssd1 vccd1 vccd1 _3221_/A sky130_fd_sc_hd__and2_1
XTAP_TAPCELL_ROW_85_958 vssd1 vccd1 sky130_fd_sc_hd__tapvpwrvgnd_1
X_4199_ _4258_/C _4211_/B _4266_/D _4199_/D vssd1 vssd1 vccd1 vccd1 _4199_/X sky130_fd_sc_hd__and4b_1
XANTENNA__2417__S _2421_/S vssd1 vssd1 vccd1 vccd1 sky130_fd_sc_hd__diode_2
XFILLER_42_359 vssd1 vssd1 vccd1 vccd1 sky130_fd_sc_hd__decap_4
XFILLER_24_55 vssd1 vssd1 vccd1 vccd1 sky130_fd_sc_hd__fill_1
XTAP_TAPCELL_ROW_40_549 vssd1 vccd1 sky130_fd_sc_hd__tapvpwrvgnd_1
XFILLER_10_245 vssd1 vssd1 vccd1 vccd1 sky130_fd_sc_hd__fill_1
XFILLER_10_278 vssd1 vssd1 vccd1 vccd1 sky130_fd_sc_hd__decap_8
XANTENNA__3950__A1 _3873_/Y vssd1 vssd1 vccd1 vccd1 sky130_fd_sc_hd__diode_2
XFILLER_77_223 vssd1 vssd1 vccd1 vccd1 sky130_fd_sc_hd__fill_1
XFILLER_2_477 vccd1 vssd1 vccd1 vssd1 sky130_ef_sc_hd__decap_12
XANTENNA__4079__S _4219_/C vssd1 vssd1 vccd1 vccd1 sky130_fd_sc_hd__diode_2
XFILLER_77_245 vssd1 vssd1 vccd1 vccd1 sky130_fd_sc_hd__fill_1
XFILLER_1_15 vssd1 vssd1 vccd1 vccd1 sky130_fd_sc_hd__fill_1
XFILLER_65_51 vssd1 vssd1 vccd1 vccd1 sky130_fd_sc_hd__decap_4
XFILLER_65_40 vssd1 vssd1 vccd1 vccd1 sky130_fd_sc_hd__decap_3
XFILLER_58_481 vssd1 vssd1 vccd1 vccd1 sky130_fd_sc_hd__fill_1
XFILLER_33_337 vssd1 vssd1 vccd1 vccd1 sky130_fd_sc_hd__decap_6
XFILLER_45_186 vssd1 vssd1 vccd1 vccd1 sky130_fd_sc_hd__fill_1
XTAP_TAPCELL_ROW_56_693 vssd1 vccd1 sky130_fd_sc_hd__tapvpwrvgnd_1
X_3570_ _4586_/Q _3603_/S _3569_/X vssd1 vssd1 vccd1 vccd1 _4586_/D sky130_fd_sc_hd__a21o_1
XANTENNA__4194__A1 _4210_/A1 vssd1 vssd1 vccd1 vccd1 sky130_fd_sc_hd__diode_2
XTAP_TAPCELL_ROW_11_284 vssd1 vccd1 sky130_fd_sc_hd__tapvpwrvgnd_1
XANTENNA__3941__A1 _3971_/A1 vssd1 vssd1 vccd1 vccd1 sky130_fd_sc_hd__diode_2
X_2521_ _2522_/A _2522_/B _2522_/C _2522_/D vssd1 vssd1 vccd1 vccd1 _2523_/A sky130_fd_sc_hd__o22ai_1
X_2452_ _4686_/Q _4673_/Q _2447_/B _4652_/Q _2445_/Y vssd1 vssd1 vccd1 vccd1 _2453_/B
+ sky130_fd_sc_hd__a221o_1
XFILLER_5_293 vssd1 vssd1 vccd1 vccd1 sky130_fd_sc_hd__decap_8
XFILLER_46_3 vssd1 vssd1 vccd1 vccd1 sky130_fd_sc_hd__fill_1
XPHY_EDGE_ROW_18_Right_18 vssd1 vssd1 vccd1 vccd1 sky130_fd_sc_hd__decap_3
X_2383_ _4559_/Q hold53/A _2425_/S vssd1 vssd1 vccd1 vccd1 _2383_/X sky130_fd_sc_hd__mux2_1
X_4122_ _4119_/X _4120_/X _4121_/Y _4122_/B1 hold110/X vssd1 vssd1 vccd1 vccd1 _4722_/D
+ sky130_fd_sc_hd__o32a_1
XTAP_TAPCELL_ROW_3_219 vssd1 vccd1 sky130_fd_sc_hd__tapvpwrvgnd_1
X_4053_ _4120_/D _4081_/A2 _4122_/B1 vssd1 vssd1 vccd1 vccd1 _4053_/Y sky130_fd_sc_hd__o21ai_1
X_3004_ _4765_/Q _4780_/Q _3004_/B1 vssd1 vssd1 vccd1 vccd1 _3007_/B sky130_fd_sc_hd__a21o_1
Xinput3 s_axis_tdata[0] vssd1 vssd1 vccd1 vccd1 input3/X sky130_fd_sc_hd__clkbuf_1
XTAP_TAPCELL_ROW_82_928 vssd1 vccd1 sky130_fd_sc_hd__tapvpwrvgnd_1
XTAP_TAPCELL_ROW_19_362 vssd1 vccd1 sky130_fd_sc_hd__tapvpwrvgnd_1
XFILLER_24_315 vssd1 vssd1 vccd1 vccd1 sky130_fd_sc_hd__decap_3
XPHY_EDGE_ROW_27_Right_27 vssd1 vssd1 vccd1 vccd1 sky130_fd_sc_hd__decap_3
X_3906_ _3983_/B2 _4022_/A2 _3905_/Y vssd1 vssd1 vccd1 vccd1 _4660_/D sky130_fd_sc_hd__a21oi_1
XANTENNA_fanout238_A _2271_/S vssd1 vssd1 vccd1 vccd1 sky130_fd_sc_hd__diode_2
X_3837_ _2916_/X _2928_/Y _2929_/Y vssd1 vssd1 vccd1 vccd1 _3837_/Y sky130_fd_sc_hd__a21oi_1
X_3768_ _3767_/C _3767_/D _3767_/A _3767_/B vssd1 vssd1 vccd1 vccd1 _3768_/Y sky130_fd_sc_hd__a22oi_4
XANTENNA_fanout405_A input2/X vssd1 vssd1 vccd1 vccd1 sky130_fd_sc_hd__diode_2
XANTENNA__3932__A1 _3971_/A1 vssd1 vssd1 vccd1 vccd1 sky130_fd_sc_hd__diode_2
X_2719_ _2678_/X _2682_/X _2717_/Y _2718_/X vssd1 vssd1 vccd1 vccd1 _2722_/B sky130_fd_sc_hd__o211a_1
X_3699_ _4528_/Q _4637_/Q vssd1 vssd1 vccd1 vccd1 _3700_/B sky130_fd_sc_hd__nand2_1
XPHY_EDGE_ROW_36_Right_36 vssd1 vssd1 vccd1 vccd1 sky130_fd_sc_hd__decap_3
XFILLER_19_109 vssd1 vssd1 vccd1 vccd1 sky130_fd_sc_hd__decap_3
XFILLER_59_278 vssd1 vssd1 vccd1 vccd1 sky130_fd_sc_hd__fill_2
XFILLER_59_289 vssd1 vssd1 vccd1 vccd1 sky130_fd_sc_hd__decap_8
XANTENNA__3448__B1 _3460_/B1 vssd1 vssd1 vccd1 vccd1 sky130_fd_sc_hd__diode_2
XFILLER_70_421 vccd1 vssd1 vccd1 vssd1 sky130_ef_sc_hd__decap_12
XFILLER_70_410 vssd1 vssd1 vccd1 vccd1 sky130_fd_sc_hd__fill_2
XPHY_EDGE_ROW_45_Right_45 vssd1 vssd1 vccd1 vccd1 sky130_fd_sc_hd__decap_3
XTAP_TAPCELL_ROW_53_663 vssd1 vccd1 sky130_fd_sc_hd__tapvpwrvgnd_1
XPHY_EDGE_ROW_54_Right_54 vssd1 vssd1 vccd1 vccd1 sky130_fd_sc_hd__decap_3
XPHY_EDGE_ROW_63_Right_63 vssd1 vssd1 vccd1 vccd1 sky130_fd_sc_hd__decap_3
XFILLER_73_281 vccd1 vssd1 vccd1 vssd1 sky130_ef_sc_hd__decap_12
XTAP_TAPCELL_ROW_16_332 vssd1 vccd1 sky130_fd_sc_hd__tapvpwrvgnd_1
XFILLER_14_392 vssd1 vssd1 vccd1 vccd1 sky130_fd_sc_hd__fill_1
X_4740_ clkload7/A _4740_/D fanout382/X vssd1 vssd1 vccd1 vccd1 _4740_/Q sky130_fd_sc_hd__dfrtp_1
X_4671_ _4687_/CLK _4671_/D fanout383/X vssd1 vssd1 vccd1 vccd1 _4671_/Q sky130_fd_sc_hd__dfrtp_1
XANTENNA__4167__A1 _4167_/A1 vssd1 vssd1 vccd1 vccd1 sky130_fd_sc_hd__diode_2
X_3622_ _4519_/Q _4628_/Q vssd1 vssd1 vccd1 vccd1 _3643_/C sky130_fd_sc_hd__xnor2_1
XPHY_EDGE_ROW_72_Right_72 vssd1 vssd1 vccd1 vccd1 sky130_fd_sc_hd__decap_3
XANTENNA__3914__A1 _2274_/A vssd1 vssd1 vccd1 vccd1 sky130_fd_sc_hd__diode_2
X_3553_ _4510_/Q _4618_/Q vssd1 vssd1 vccd1 vccd1 _3553_/Y sky130_fd_sc_hd__nor2_1
X_3484_ _4568_/Q _3522_/A2 _3482_/X _3483_/X vssd1 vssd1 vccd1 vccd1 _4568_/D sky130_fd_sc_hd__a22o_1
X_2504_ _4704_/Q _2483_/B _2482_/A vssd1 vssd1 vccd1 vccd1 _2505_/B sky130_fd_sc_hd__a21o_1
X_2435_ _4651_/Q _3798_/B _2434_/A vssd1 vssd1 vccd1 vccd1 _2435_/Y sky130_fd_sc_hd__a21oi_1
XFILLER_84_513 vssd1 vssd1 vccd1 vccd1 sky130_fd_sc_hd__decap_6
X_2366_ hold16/X _2365_/X _2366_/S vssd1 vssd1 vccd1 vccd1 _4478_/D sky130_fd_sc_hd__mux2_1
X_4105_ _4372_/A _4105_/A2 _4225_/B2 vssd1 vssd1 vccd1 vccd1 _4105_/Y sky130_fd_sc_hd__o21ai_1
XPHY_EDGE_ROW_81_Right_81 vssd1 vssd1 vccd1 vccd1 sky130_fd_sc_hd__decap_3
X_2297_ _2296_/Y _2295_/X _2294_/X hold163/X _3999_/B2 vssd1 vssd1 vccd1 vccd1 _4456_/D
+ sky130_fd_sc_hd__o32a_1
X_4036_ _4036_/A0 _4036_/A1 _4036_/S vssd1 vssd1 vccd1 vccd1 _4036_/X sky130_fd_sc_hd__mux2_1
XFILLER_56_259 vssd1 vssd1 vccd1 vccd1 sky130_fd_sc_hd__fill_1
XTAP_TAPCELL_ROW_67_788 vssd1 vccd1 sky130_fd_sc_hd__tapvpwrvgnd_1
XFILLER_52_421 vssd1 vssd1 vccd1 vccd1 sky130_fd_sc_hd__fill_1
XANTENNA__4182__S _4789_/Q vssd1 vssd1 vccd1 vccd1 sky130_fd_sc_hd__diode_2
XANTENNA_fanout310_X _4223_/C vssd1 vssd1 vccd1 vccd1 sky130_fd_sc_hd__diode_2
XFILLER_21_34 vssd1 vssd1 vccd1 vccd1 sky130_fd_sc_hd__fill_1
XANTENNA__4330__B2 _4338_/A2 vssd1 vssd1 vccd1 vccd1 sky130_fd_sc_hd__diode_2
XTAP_TAPCELL_ROW_58_711 vssd1 vccd1 sky130_fd_sc_hd__tapvpwrvgnd_1
XFILLER_28_440 vccd1 vssd1 vccd1 vssd1 sky130_ef_sc_hd__decap_12
XFILLER_43_443 vssd1 vssd1 vccd1 vccd1 sky130_fd_sc_hd__decap_4
XFILLER_46_97 vssd1 vssd1 vccd1 vccd1 sky130_fd_sc_hd__decap_4
XFILLER_55_281 vssd1 vssd1 vccd1 vccd1 sky130_fd_sc_hd__decap_8
XTAP_TAPCELL_ROW_13_302 vssd1 vccd1 sky130_fd_sc_hd__tapvpwrvgnd_1
XANTENNA__4149__A1 _4215_/C vssd1 vssd1 vccd1 vccd1 sky130_fd_sc_hd__diode_2
XFILLER_7_69 vssd1 vssd1 vccd1 vccd1 sky130_fd_sc_hd__fill_2
XFILLER_7_388 vssd1 vssd1 vccd1 vccd1 sky130_fd_sc_hd__decap_4
X_2220_ hold90/A vssd1 vssd1 vccd1 vccd1 _2599_/B sky130_fd_sc_hd__inv_2
XANTENNA__4321__A1 _4320_/A vssd1 vssd1 vccd1 vccd1 sky130_fd_sc_hd__diode_2
XANTENNA__2332__B1 _3975_/S vssd1 vssd1 vccd1 vccd1 sky130_fd_sc_hd__diode_2
XFILLER_81_505 vccd1 vssd1 vccd1 vssd1 sky130_ef_sc_hd__decap_12
XTAP_TAPCELL_ROW_64_769 vssd1 vccd1 sky130_fd_sc_hd__tapvpwrvgnd_1
XFILLER_61_262 vssd1 vssd1 vccd1 vccd1 sky130_fd_sc_hd__fill_1
X_2984_ _2971_/Y _2983_/Y _2985_/A2 vssd1 vssd1 vccd1 vccd1 _2984_/Y sky130_fd_sc_hd__o21ai_1
XFILLER_21_159 vssd1 vssd1 vccd1 vccd1 sky130_fd_sc_hd__decap_8
XANTENNA__3596__C1 _3613_/B vssd1 vssd1 vccd1 vccd1 sky130_fd_sc_hd__diode_2
X_4723_ clkload6/A _4723_/D fanout380/X vssd1 vssd1 vccd1 vccd1 hold79/A sky130_fd_sc_hd__dfrtp_1
X_4654_ clkload4/A _4654_/D fanout378/X vssd1 vssd1 vccd1 vccd1 _4654_/Q sky130_fd_sc_hd__dfrtp_1
X_4585_ _4587_/CLK _4585_/D fanout408/X vssd1 vssd1 vccd1 vccd1 _4585_/Q sky130_fd_sc_hd__dfrtp_2
X_3605_ _4517_/Q _4626_/Q vssd1 vssd1 vccd1 vccd1 _3605_/Y sky130_fd_sc_hd__nor2_1
XANTENNA__2250__S _2250_/S vssd1 vssd1 vccd1 vccd1 sky130_fd_sc_hd__diode_2
X_3536_ _3330_/X _3536_/A2 _3535_/Y _3536_/B1 vssd1 vssd1 vccd1 vccd1 _3536_/Y sky130_fd_sc_hd__a31oi_1
XPHY_EDGE_ROW_10_Left_98 vssd1 vssd1 vccd1 vccd1 sky130_fd_sc_hd__decap_3
X_3467_ _4565_/Q _3540_/B2 _3465_/X _3466_/X vssd1 vssd1 vccd1 vccd1 _4565_/D sky130_fd_sc_hd__a22o_1
X_2418_ hold68/X _2417_/X _2420_/S vssd1 vssd1 vccd1 vccd1 _4504_/D sky130_fd_sc_hd__mux2_1
XFILLER_69_362 vssd1 vssd1 vccd1 vccd1 sky130_fd_sc_hd__fill_1
X_3398_ _3398_/A _3398_/B vssd1 vssd1 vccd1 vccd1 _3398_/X sky130_fd_sc_hd__xor2_1
X_2349_ _4542_/Q hold36/A _2365_/S vssd1 vssd1 vccd1 vccd1 _2349_/X sky130_fd_sc_hd__mux2_1
XFILLER_29_259 vssd1 vssd1 vccd1 vccd1 sky130_fd_sc_hd__fill_1
XFILLER_84_365 vccd1 vssd1 vccd1 vssd1 sky130_ef_sc_hd__decap_12
X_4019_ _4018_/Y _4017_/X _4016_/X hold141/X _4138_/B1 vssd1 vssd1 vccd1 vccd1 _4696_/D
+ sky130_fd_sc_hd__o32a_1
XFILLER_37_281 vssd1 vssd1 vccd1 vccd1 sky130_fd_sc_hd__decap_4
XPHY_EDGE_ROW_0_Right_0 vssd1 vssd1 vccd1 vccd1 sky130_fd_sc_hd__decap_3
XANTENNA__4000__A0 _4020_/A0 vssd1 vssd1 vccd1 vccd1 sky130_fd_sc_hd__diode_2
XANTENNA__4298__D _4364_/A vssd1 vssd1 vccd1 vccd1 sky130_fd_sc_hd__diode_2
XFILLER_87_181 vccd1 vssd1 vccd1 vssd1 sky130_ef_sc_hd__decap_12
XANTENNA_input33_A s_axis_tdata[8] vssd1 vssd1 vccd1 vccd1 sky130_fd_sc_hd__diode_2
XANTENNA__4087__S _4087_/S vssd1 vssd1 vccd1 vccd1 sky130_fd_sc_hd__diode_2
XFILLER_16_421 vccd1 vssd1 vccd1 vssd1 sky130_ef_sc_hd__decap_12
XTAP_TAPCELL_ROW_61_739 vssd1 vccd1 sky130_fd_sc_hd__tapvpwrvgnd_1
Xhold108 _4709_/Q vssd1 vssd1 vccd1 vccd1 hold108/X sky130_fd_sc_hd__dlygate4sd3_1
X_4370_ _4369_/Y _4368_/X _4367_/X _4785_/Q _4378_/B2 vssd1 vssd1 vccd1 vccd1 _4785_/D
+ sky130_fd_sc_hd__o32a_1
Xhold119 _4771_/Q vssd1 vssd1 vccd1 vccd1 hold119/X sky130_fd_sc_hd__dlygate4sd3_1
X_3321_ _3322_/B vssd1 vssd1 vccd1 vccd1 _3531_/B sky130_fd_sc_hd__inv_2
XANTENNA__4001__D _4063_/S vssd1 vssd1 vccd1 vccd1 sky130_fd_sc_hd__diode_2
XTAP_TAPCELL_ROW_69_806 vssd1 vccd1 sky130_fd_sc_hd__tapvpwrvgnd_1
X_3252_ _3221_/B _3226_/C _3221_/A vssd1 vssd1 vccd1 vccd1 _3252_/Y sky130_fd_sc_hd__o21bai_1
XFILLER_78_170 vssd1 vssd1 vccd1 vccd1 sky130_fd_sc_hd__decap_6
X_3183_ _3474_/A _3481_/B vssd1 vssd1 vccd1 vccd1 _3301_/D sky130_fd_sc_hd__nand2_1
XFILLER_81_302 vssd1 vssd1 vccd1 vccd1 sky130_fd_sc_hd__decap_3
XTAP_TAPCELL_ROW_77_883 vssd1 vccd1 sky130_fd_sc_hd__tapvpwrvgnd_1
XFILLER_19_281 vssd1 vssd1 vccd1 vccd1 sky130_fd_sc_hd__fill_1
XTAP_TAPCELL_ROW_24_408 vssd1 vccd1 sky130_fd_sc_hd__tapvpwrvgnd_1
XFILLER_34_284 vssd1 vssd1 vccd1 vccd1 sky130_fd_sc_hd__fill_2
XANTENNA__3569__C1 _3549_/A vssd1 vssd1 vccd1 vccd1 sky130_fd_sc_hd__diode_2
X_2967_ _2960_/Y _2961_/X _2967_/C _2967_/D vssd1 vssd1 vccd1 vccd1 _2969_/A sky130_fd_sc_hd__and4bb_1
XTAP_TAPCELL_ROW_32_474 vssd1 vccd1 sky130_fd_sc_hd__tapvpwrvgnd_1
XANTENNA_fanout318_A _3950_/A2 vssd1 vssd1 vccd1 vccd1 sky130_fd_sc_hd__diode_2
X_4706_ clkload3/A _4706_/D fanout376/X vssd1 vssd1 vccd1 vccd1 _4706_/Q sky130_fd_sc_hd__dfrtp_1
X_2898_ _2917_/B _2884_/X _2861_/B _2862_/Y vssd1 vssd1 vccd1 vccd1 _2899_/B sky130_fd_sc_hd__o211ai_1
X_4637_ _4640_/CLK _4637_/D fanout425/X vssd1 vssd1 vccd1 vccd1 _4637_/Q sky130_fd_sc_hd__dfrtp_2
X_4568_ _4613_/CLK _4568_/D fanout429/X vssd1 vssd1 vccd1 vccd1 _4568_/Q sky130_fd_sc_hd__dfrtp_2
XANTENNA_fanout106_X _3534_/A2 vssd1 vssd1 vccd1 vccd1 sky130_fd_sc_hd__diode_2
X_4499_ _4575_/CLK _4499_/D fanout436/X vssd1 vssd1 vccd1 vccd1 hold66/A sky130_fd_sc_hd__dfrtp_1
X_3519_ _3307_/X _3516_/B _3313_/D _3309_/B vssd1 vssd1 vccd1 vccd1 _3524_/C sky130_fd_sc_hd__o211ai_2
XFILLER_27_44 vccd1 vssd1 vccd1 vssd1 sky130_ef_sc_hd__decap_12
XFILLER_84_184 vssd1 vssd1 vccd1 vccd1 sky130_fd_sc_hd__fill_1
XFILLER_72_368 vccd1 vssd1 vccd1 vssd1 sky130_ef_sc_hd__decap_12
XFILLER_40_221 vccd1 vssd1 vccd1 vssd1 sky130_ef_sc_hd__decap_12
Xclkbuf_leaf_20_clk clkbuf_2_3__f_clk/X vssd1 vssd1 vccd1 vccd1 _4609_/CLK sky130_fd_sc_hd__clkbuf_8
XFILLER_4_100 vccd1 vssd1 vccd1 vssd1 sky130_ef_sc_hd__decap_12
XFILLER_4_37 vccd1 vssd1 vccd1 vssd1 sky130_ef_sc_hd__decap_12
XFILLER_0_361 vssd1 vssd1 vccd1 vccd1 sky130_fd_sc_hd__decap_3
XFILLER_48_321 vccd1 vssd1 vccd1 vssd1 sky130_ef_sc_hd__decap_12
XFILLER_48_365 vssd1 vssd1 vccd1 vccd1 sky130_fd_sc_hd__decap_8
XFILLER_84_72 vssd1 vssd1 vccd1 vccd1 sky130_fd_sc_hd__fill_1
XFILLER_75_195 vccd1 vssd1 vccd1 vssd1 sky130_ef_sc_hd__decap_12
XFILLER_63_335 vssd1 vssd1 vccd1 vccd1 sky130_fd_sc_hd__fill_1
XTAP_TAPCELL_ROW_74_853 vssd1 vccd1 sky130_fd_sc_hd__tapvpwrvgnd_1
XTAP_TAPCELL_ROW_46_599 vssd1 vccd1 sky130_fd_sc_hd__tapvpwrvgnd_1
X_3870_ _4581_/Q _3613_/B _2369_/S _3870_/B1 vssd1 vssd1 vccd1 vccd1 _4648_/D sky130_fd_sc_hd__a31o_1
X_2821_ _2819_/Y _2820_/X _2767_/C _2767_/Y vssd1 vssd1 vccd1 vccd1 _2823_/A sky130_fd_sc_hd__o211a_1
X_2752_ _2753_/A _2753_/B _2753_/C _2753_/D vssd1 vssd1 vccd1 vccd1 _2754_/B sky130_fd_sc_hd__a22o_1
Xclkbuf_leaf_11_clk clkload1/A vssd1 vssd1 vccd1 vccd1 _4748_/CLK sky130_fd_sc_hd__clkbuf_8
XFILLER_8_461 vccd1 vssd1 vccd1 vssd1 sky130_ef_sc_hd__decap_12
X_4422_ _4553_/CLK _4422_/D fanout419/X vssd1 vssd1 vccd1 vccd1 hold27/A sky130_fd_sc_hd__dfrtp_1
X_2683_ _2648_/C _2649_/B _2681_/Y _2682_/X vssd1 vssd1 vccd1 vccd1 _2724_/A sky130_fd_sc_hd__a211o_1
X_4353_ _4352_/A _4372_/B _4358_/A2 vssd1 vssd1 vccd1 vccd1 _4353_/Y sky130_fd_sc_hd__o21ai_1
X_3304_ _4573_/Q _3308_/B vssd1 vssd1 vccd1 vccd1 _3511_/C sky130_fd_sc_hd__xor2_1
Xfanout429 fanout430/X vssd1 vssd1 vccd1 vccd1 fanout429/X sky130_fd_sc_hd__clkbuf_4
X_4284_ _4283_/Y _4282_/X _4281_/X _4763_/Q _4295_/B1 vssd1 vssd1 vccd1 vccd1 _4763_/D
+ sky130_fd_sc_hd__o32a_1
Xfanout418 fanout424/X vssd1 vssd1 vccd1 vccd1 fanout418/X sky130_fd_sc_hd__clkbuf_2
Xfanout407 fanout414/X vssd1 vssd1 vccd1 vccd1 fanout407/X sky130_fd_sc_hd__buf_2
X_3235_ _3231_/A _3231_/B _3406_/A _3406_/B vssd1 vssd1 vccd1 vccd1 _3286_/B sky130_fd_sc_hd__a211o_1
X_3166_ _3166_/A _3166_/B vssd1 vssd1 vccd1 vccd1 _3168_/A sky130_fd_sc_hd__nand2_1
XFILLER_27_505 vssd1 vssd1 vccd1 vccd1 sky130_fd_sc_hd__fill_1
X_3097_ _4785_/Q _4770_/Q vssd1 vssd1 vccd1 vccd1 _3098_/B sky130_fd_sc_hd__nor2_1
XFILLER_66_195 vssd1 vssd1 vccd1 vccd1 sky130_fd_sc_hd__fill_1
XTAP_TAPCELL_ROW_37_522 vssd1 vccd1 sky130_fd_sc_hd__tapvpwrvgnd_1
XANTENNA_fanout268_A _4813_/Q vssd1 vssd1 vccd1 vccd1 sky130_fd_sc_hd__diode_2
XANTENNA_fanout435_A fanout440/X vssd1 vssd1 vccd1 vccd1 sky130_fd_sc_hd__diode_2
X_3999_ _3998_/Y _3997_/X _3996_/X hold146/X _3999_/B2 vssd1 vssd1 vccd1 vccd1 _4691_/D
+ sky130_fd_sc_hd__o32a_1
XANTENNA__4190__S _4323_/S vssd1 vssd1 vccd1 vccd1 sky130_fd_sc_hd__diode_2
XANTENNA__4203__B _4211_/B vssd1 vssd1 vccd1 vccd1 sky130_fd_sc_hd__diode_2
XFILLER_1_125 vccd1 vssd1 vccd1 vssd1 sky130_ef_sc_hd__decap_12
XFILLER_77_405 vssd1 vssd1 vccd1 vccd1 sky130_fd_sc_hd__fill_1
XTAP_TAPCELL_ROW_9_269 vssd1 vccd1 sky130_fd_sc_hd__tapvpwrvgnd_1
XFILLER_77_438 vssd1 vssd1 vccd1 vccd1 sky130_fd_sc_hd__decap_8
XFILLER_77_427 vssd1 vssd1 vccd1 vccd1 sky130_fd_sc_hd__fill_2
XFILLER_1_169 vssd1 vssd1 vccd1 vccd1 sky130_fd_sc_hd__fill_1
XFILLER_77_449 vssd1 vssd1 vccd1 vccd1 sky130_fd_sc_hd__decap_8
XFILLER_85_460 vssd1 vssd1 vccd1 vccd1 sky130_fd_sc_hd__decap_6
XANTENNA__2296__A2 _2323_/B vssd1 vssd1 vccd1 vccd1 sky130_fd_sc_hd__diode_2
XFILLER_45_324 vssd1 vssd1 vccd1 vccd1 sky130_fd_sc_hd__fill_1
XFILLER_45_335 vssd1 vssd1 vccd1 vccd1 sky130_fd_sc_hd__fill_1
XFILLER_72_187 vssd1 vssd1 vccd1 vccd1 sky130_fd_sc_hd__decap_3
XTAP_TAPCELL_ROW_0_180 vssd1 vccd1 sky130_fd_sc_hd__tapvpwrvgnd_1
XFILLER_13_221 vssd1 vssd1 vccd1 vccd1 sky130_fd_sc_hd__fill_1
XTAP_TAPCELL_ROW_0_191 vssd1 vccd1 sky130_fd_sc_hd__tapvpwrvgnd_1
XFILLER_54_97 vssd1 vssd1 vccd1 vccd1 sky130_fd_sc_hd__decap_8
XFILLER_13_298 vssd1 vssd1 vccd1 vccd1 sky130_fd_sc_hd__decap_4
Xclkload17 _4771_/CLK vssd1 vssd1 vccd1 vccd1 clkload17/Y sky130_fd_sc_hd__clkinv_4
Xclkload39 _4609_/CLK vssd1 vssd1 vccd1 vccd1 clkload39/Y sky130_fd_sc_hd__inv_8
Xclkload28 _4597_/CLK vssd1 vssd1 vccd1 vccd1 clkload28/Y sky130_fd_sc_hd__inv_6
XANTENNA__2508__B1 _4666_/Q vssd1 vssd1 vccd1 vccd1 sky130_fd_sc_hd__diode_2
XTAP_TAPCELL_ROW_79_901 vssd1 vccd1 sky130_fd_sc_hd__tapvpwrvgnd_1
XANTENNA__3720__A2 _3549_/A vssd1 vssd1 vccd1 vccd1 sky130_fd_sc_hd__diode_2
XFILLER_83_419 vssd1 vssd1 vccd1 vccd1 sky130_fd_sc_hd__fill_2
XFILLER_76_460 vccd1 vssd1 vccd1 vssd1 sky130_ef_sc_hd__decap_12
X_3020_ _3061_/B _3018_/B _3074_/C vssd1 vssd1 vccd1 vccd1 _3021_/B sky130_fd_sc_hd__o21ai_1
Xclkbuf_leaf_0_clk clkload0/A vssd1 vssd1 vccd1 vccd1 clkload3/A sky130_fd_sc_hd__clkbuf_8
XFILLER_63_110 vssd1 vssd1 vccd1 vccd1 sky130_fd_sc_hd__fill_2
XFILLER_63_198 vccd1 vssd1 vccd1 vssd1 sky130_ef_sc_hd__decap_12
X_3922_ _4581_/Q _4666_/Q _2369_/S _3922_/B1 vssd1 vssd1 vccd1 vccd1 _4666_/D sky130_fd_sc_hd__a31o_1
X_3853_ _3126_/X _3136_/Y _3135_/Y vssd1 vssd1 vccd1 vccd1 _3853_/Y sky130_fd_sc_hd__o21ai_1
X_2804_ _4760_/Q _4775_/Q vssd1 vssd1 vccd1 vccd1 _2804_/Y sky130_fd_sc_hd__nand2_1
X_3784_ _3784_/A1 _3543_/B _3784_/B1 vssd1 vssd1 vccd1 vccd1 _3784_/Y sky130_fd_sc_hd__a21oi_1
X_2735_ _2786_/C _2735_/B vssd1 vssd1 vccd1 vccd1 _2735_/Y sky130_fd_sc_hd__nor2_1
X_2666_ _2662_/X _2664_/Y _4464_/Q vssd1 vssd1 vccd1 vccd1 _2668_/D sky130_fd_sc_hd__o21bai_1
X_4405_ _4239_/B input21/X _4408_/S vssd1 vssd1 vccd1 vccd1 _4814_/D sky130_fd_sc_hd__mux2_1
Xfanout204 _2278_/Y vssd1 vssd1 vccd1 vccd1 _3875_/A0 sky130_fd_sc_hd__clkbuf_2
X_2597_ _4739_/Q _4709_/Q vssd1 vssd1 vccd1 vccd1 _2599_/C sky130_fd_sc_hd__and2_1
X_4336_ _4336_/A _4344_/B vssd1 vssd1 vccd1 vccd1 _4336_/Y sky130_fd_sc_hd__nor2_1
Xfanout226 _4173_/A2 vssd1 vssd1 vccd1 vccd1 _4176_/A2 sky130_fd_sc_hd__buf_2
XTAP_TAPCELL_ROW_6_239 vssd1 vccd1 sky130_fd_sc_hd__tapvpwrvgnd_1
Xfanout237 _2250_/S vssd1 vssd1 vccd1 vccd1 _2242_/S sky130_fd_sc_hd__clkbuf_4
Xfanout215 _2228_/Y vssd1 vssd1 vccd1 vccd1 fanout215/X sky130_fd_sc_hd__dlymetal6s2s_1
XANTENNA_fanout385_A fanout388/X vssd1 vssd1 vccd1 vccd1 sky130_fd_sc_hd__diode_2
Xfanout248 _2227_/X vssd1 vssd1 vccd1 vccd1 fanout248/X sky130_fd_sc_hd__buf_1
X_4267_ _4266_/D _4279_/A2 _4334_/A2 vssd1 vssd1 vccd1 vccd1 _4267_/Y sky130_fd_sc_hd__o21ai_1
Xfanout259 _4815_/Q vssd1 vssd1 vccd1 vccd1 _4258_/C sky130_fd_sc_hd__buf_2
X_4198_ _4214_/A0 _4210_/A1 _4203_/C vssd1 vssd1 vccd1 vccd1 _4198_/X sky130_fd_sc_hd__mux2_1
X_3218_ _3295_/A _3197_/X _3217_/X _3216_/X _3214_/X vssd1 vssd1 vccd1 vccd1 _3302_/B
+ sky130_fd_sc_hd__a311oi_4
X_3149_ _4785_/Q _4770_/Q _3130_/A _3133_/B vssd1 vssd1 vccd1 vccd1 _3153_/A sky130_fd_sc_hd__a31o_1
XFILLER_24_23 vssd1 vssd1 vccd1 vccd1 sky130_fd_sc_hd__fill_1
XANTENNA_fanout340_X _4324_/A vssd1 vssd1 vccd1 vccd1 sky130_fd_sc_hd__diode_2
XFILLER_24_45 vssd1 vssd1 vccd1 vccd1 sky130_fd_sc_hd__fill_1
XFILLER_10_235 vssd1 vssd1 vccd1 vccd1 sky130_fd_sc_hd__fill_1
XANTENNA__3950__A2 _3950_/A2 vssd1 vssd1 vccd1 vccd1 sky130_fd_sc_hd__diode_2
XFILLER_2_489 vccd1 vssd1 vccd1 vssd1 sky130_ef_sc_hd__decap_12
XFILLER_77_235 vssd1 vssd1 vccd1 vccd1 sky130_fd_sc_hd__fill_1
XTAP_TAPCELL_ROW_48_617 vssd1 vccd1 sky130_fd_sc_hd__tapvpwrvgnd_1
XFILLER_60_102 vccd1 vssd1 vccd1 vssd1 sky130_ef_sc_hd__decap_12
XTAP_TAPCELL_ROW_56_694 vssd1 vccd1 sky130_fd_sc_hd__tapvpwrvgnd_1
XFILLER_60_157 vssd1 vssd1 vccd1 vccd1 sky130_fd_sc_hd__decap_6
XFILLER_41_382 vssd1 vssd1 vccd1 vccd1 sky130_fd_sc_hd__fill_2
XTAP_TAPCELL_ROW_11_285 vssd1 vccd1 sky130_fd_sc_hd__tapvpwrvgnd_1
X_2520_ _2519_/A _2519_/B _4662_/Q vssd1 vssd1 vccd1 vccd1 _2522_/D sky130_fd_sc_hd__o21ba_1
X_2451_ _4686_/Q _4673_/Q _4454_/Q _4652_/Q vssd1 vssd1 vccd1 vccd1 _2473_/A sky130_fd_sc_hd__nand4_1
XANTENNA_clkbuf_leaf_17_clk_A clkload1/A vssd1 vssd1 vccd1 vccd1 sky130_fd_sc_hd__diode_2
X_2382_ hold3/X _2381_/X _2382_/S vssd1 vssd1 vccd1 vccd1 _4486_/D sky130_fd_sc_hd__mux2_1
X_4121_ _4120_/D _4173_/A2 _4122_/B1 vssd1 vssd1 vccd1 vccd1 _4121_/Y sky130_fd_sc_hd__o21ai_1
X_4052_ _4116_/D _4120_/D _4068_/B _4056_/D vssd1 vssd1 vccd1 vccd1 _4052_/X sky130_fd_sc_hd__and4b_1
Xinput4 s_axis_tdata[10] vssd1 vssd1 vccd1 vccd1 input4/X sky130_fd_sc_hd__clkbuf_1
X_3003_ _2964_/B _2964_/A _2964_/C vssd1 vssd1 vccd1 vccd1 _3003_/X sky130_fd_sc_hd__o21ba_1
XTAP_TAPCELL_ROW_82_929 vssd1 vccd1 sky130_fd_sc_hd__tapvpwrvgnd_1
XTAP_TAPCELL_ROW_19_363 vssd1 vccd1 sky130_fd_sc_hd__tapvpwrvgnd_1
Xclkbuf_2_1__f_clk clkbuf_0_clk/X vssd1 vssd1 vccd1 vccd1 clkload1/A sky130_fd_sc_hd__clkbuf_16
XFILLER_51_113 vssd1 vssd1 vccd1 vccd1 sky130_fd_sc_hd__fill_1
X_3905_ _3943_/A2 _3946_/A1 hold224/X vssd1 vssd1 vccd1 vccd1 _3905_/Y sky130_fd_sc_hd__a21oi_1
X_3836_ _4636_/Q _3848_/A2 _2900_/X _3835_/Y vssd1 vssd1 vccd1 vccd1 _4636_/D sky130_fd_sc_hd__a22o_1
X_3767_ _3767_/A _3767_/B _3767_/C _3767_/D vssd1 vssd1 vccd1 vccd1 _3767_/X sky130_fd_sc_hd__and4_1
XANTENNA_fanout300_A _4802_/Q vssd1 vssd1 vccd1 vccd1 sky130_fd_sc_hd__diode_2
X_2718_ _4726_/Q _2673_/B _2717_/B _2717_/C _2672_/A vssd1 vssd1 vccd1 vccd1 _2718_/X
+ sky130_fd_sc_hd__a221o_1
XFILLER_10_36 vssd1 vssd1 vccd1 vccd1 sky130_fd_sc_hd__decap_6
X_3698_ _4528_/Q _4637_/Q vssd1 vssd1 vccd1 vccd1 _3729_/A sky130_fd_sc_hd__nor2_1
X_2649_ _2649_/A _2649_/B vssd1 vssd1 vccd1 vccd1 _2651_/B sky130_fd_sc_hd__and2_1
XFILLER_86_29 vccd1 vssd1 vccd1 vssd1 sky130_ef_sc_hd__decap_12
XANTENNA_fanout290_X _4001_/B vssd1 vssd1 vccd1 vccd1 sky130_fd_sc_hd__diode_2
X_4319_ _4339_/A0 _4343_/A1 _4324_/A vssd1 vssd1 vccd1 vccd1 _4319_/X sky130_fd_sc_hd__mux2_1
XANTENNA_fanout388_X fanout388/X vssd1 vssd1 vccd1 vccd1 sky130_fd_sc_hd__diode_2
XANTENNA__3448__A1 _3460_/A1 vssd1 vssd1 vccd1 vccd1 sky130_fd_sc_hd__diode_2
XFILLER_82_260 vccd1 vssd1 vccd1 vssd1 sky130_ef_sc_hd__decap_12
XFILLER_70_444 vssd1 vssd1 vccd1 vccd1 sky130_fd_sc_hd__decap_4
XFILLER_70_433 vssd1 vssd1 vccd1 vccd1 sky130_fd_sc_hd__decap_4
XFILLER_42_113 vssd1 vssd1 vccd1 vccd1 sky130_fd_sc_hd__decap_6
XFILLER_42_179 vssd1 vssd1 vccd1 vccd1 sky130_fd_sc_hd__decap_3
XTAP_TAPCELL_ROW_53_664 vssd1 vccd1 sky130_fd_sc_hd__tapvpwrvgnd_1
XANTENNA__4176__A2 _4176_/A2 vssd1 vssd1 vccd1 vccd1 sky130_fd_sc_hd__diode_2
XPHY_EDGE_ROW_29_Left_117 vssd1 vssd1 vccd1 vccd1 sky130_fd_sc_hd__decap_3
XFILLER_38_419 vssd1 vssd1 vccd1 vccd1 sky130_fd_sc_hd__fill_1
XFILLER_73_293 vccd1 vssd1 vccd1 vssd1 sky130_ef_sc_hd__decap_12
XFILLER_61_444 vssd1 vssd1 vccd1 vccd1 sky130_fd_sc_hd__fill_2
XFILLER_18_187 vssd1 vssd1 vccd1 vccd1 sky130_fd_sc_hd__fill_2
XFILLER_33_113 vssd1 vssd1 vccd1 vccd1 sky130_fd_sc_hd__decap_8
XPHY_EDGE_ROW_38_Left_126 vssd1 vssd1 vccd1 vccd1 sky130_fd_sc_hd__decap_3
XTAP_TAPCELL_ROW_16_333 vssd1 vccd1 sky130_fd_sc_hd__tapvpwrvgnd_1
X_4670_ _4687_/CLK _4670_/D fanout383/X vssd1 vssd1 vccd1 vccd1 _4670_/Q sky130_fd_sc_hd__dfrtp_1
X_3621_ _4519_/Q _4628_/Q vssd1 vssd1 vccd1 vccd1 _3621_/Y sky130_fd_sc_hd__nand2_1
X_3552_ _4510_/Q _4618_/Q vssd1 vssd1 vccd1 vccd1 _3558_/B sky130_fd_sc_hd__nand2_1
XANTENNA__3914__A2 _3946_/A1 vssd1 vssd1 vccd1 vccd1 sky130_fd_sc_hd__diode_2
X_2503_ _4689_/Q _4676_/Q _2478_/Y vssd1 vssd1 vccd1 vccd1 _2505_/A sky130_fd_sc_hd__a21bo_1
X_3483_ _4609_/Q _3503_/A2 _3504_/B1 _3784_/A1 vssd1 vssd1 vccd1 vccd1 _3483_/X sky130_fd_sc_hd__o211a_1
XPHY_EDGE_ROW_47_Left_135 vssd1 vssd1 vccd1 vccd1 sky130_fd_sc_hd__decap_3
X_2434_ _2434_/A _2434_/B vssd1 vssd1 vccd1 vccd1 _3798_/B sky130_fd_sc_hd__nor2_1
X_2365_ _4550_/Q hold56/A _2365_/S vssd1 vssd1 vccd1 vccd1 _2365_/X sky130_fd_sc_hd__mux2_1
X_4104_ _4175_/C _4104_/B _4104_/C _4372_/A vssd1 vssd1 vccd1 vccd1 _4104_/X sky130_fd_sc_hd__and4b_1
X_2296_ _4123_/S _2323_/B _3999_/B2 vssd1 vssd1 vccd1 vccd1 _2296_/Y sky130_fd_sc_hd__o21ai_1
X_4035_ _4034_/Y _4033_/X _4032_/X hold201/X _4039_/B2 vssd1 vssd1 vccd1 vccd1 _4700_/D
+ sky130_fd_sc_hd__o32a_1
XFILLER_37_441 vssd1 vssd1 vccd1 vccd1 sky130_fd_sc_hd__decap_3
XANTENNA__4564__RESET_B fanout435/X vssd1 vssd1 vccd1 vccd1 sky130_fd_sc_hd__diode_2
XTAP_TAPCELL_ROW_67_789 vssd1 vccd1 sky130_fd_sc_hd__tapvpwrvgnd_1
XFILLER_37_485 vssd1 vssd1 vccd1 vccd1 sky130_fd_sc_hd__fill_1
XPHY_EDGE_ROW_56_Left_144 vssd1 vssd1 vccd1 vccd1 sky130_fd_sc_hd__decap_3
X_3819_ _2615_/Y _2623_/Y _2624_/Y vssd1 vssd1 vccd1 vccd1 _3819_/Y sky130_fd_sc_hd__a21oi_1
X_4799_ _4815_/CLK _4799_/D fanout395/X vssd1 vssd1 vccd1 vccd1 _4799_/Q sky130_fd_sc_hd__dfrtp_4
XPHY_EDGE_ROW_65_Left_153 vssd1 vssd1 vccd1 vccd1 sky130_fd_sc_hd__decap_3
XANTENNA__3905__A2 _3946_/A1 vssd1 vssd1 vccd1 vccd1 sky130_fd_sc_hd__diode_2
XFILLER_21_57 vssd1 vssd1 vccd1 vccd1 sky130_fd_sc_hd__decap_4
XANTENNA__4211__B _4211_/B vssd1 vssd1 vccd1 vccd1 sky130_fd_sc_hd__diode_2
XFILLER_87_385 vssd1 vssd1 vccd1 vccd1 sky130_fd_sc_hd__decap_6
XTAP_TAPCELL_ROW_58_712 vssd1 vccd1 sky130_fd_sc_hd__tapvpwrvgnd_1
XPHY_EDGE_ROW_74_Left_162 vssd1 vssd1 vccd1 vccd1 sky130_fd_sc_hd__decap_3
XFILLER_47_238 vssd1 vssd1 vccd1 vccd1 sky130_fd_sc_hd__decap_6
XFILLER_15_102 vssd1 vssd1 vccd1 vccd1 sky130_fd_sc_hd__decap_4
XFILLER_70_230 vccd1 vssd1 vccd1 vssd1 sky130_ef_sc_hd__decap_12
XTAP_TAPCELL_ROW_13_303 vssd1 vccd1 sky130_fd_sc_hd__tapvpwrvgnd_1
XANTENNA__4149__A2 _4176_/A2 vssd1 vssd1 vccd1 vccd1 sky130_fd_sc_hd__diode_2
XPHY_EDGE_ROW_83_Left_171 vssd1 vssd1 vccd1 vccd1 sky130_fd_sc_hd__decap_3
XTAP_TAPCELL_ROW_21_380 vssd1 vccd1 sky130_fd_sc_hd__tapvpwrvgnd_1
XFILLER_87_83 vssd1 vssd1 vccd1 vccd1 sky130_fd_sc_hd__fill_1
XANTENNA__2857__A _2857_/A vssd1 vssd1 vccd1 vccd1 sky130_fd_sc_hd__diode_2
XFILLER_16_5 vssd1 vssd1 vccd1 vccd1 sky130_fd_sc_hd__fill_1
XANTENNA__4085__A1 _4219_/C vssd1 vssd1 vccd1 vccd1 sky130_fd_sc_hd__diode_2
XFILLER_81_517 vssd1 vssd1 vccd1 vccd1 sky130_fd_sc_hd__fill_2
XFILLER_53_208 vssd1 vssd1 vccd1 vccd1 sky130_fd_sc_hd__decap_3
XFILLER_46_282 vssd1 vssd1 vccd1 vccd1 sky130_fd_sc_hd__fill_2
XFILLER_61_241 vssd1 vssd1 vccd1 vccd1 sky130_fd_sc_hd__fill_1
X_2983_ _2940_/A _2942_/A _2980_/X _2981_/Y _3000_/B vssd1 vssd1 vccd1 vccd1 _2983_/Y
+ sky130_fd_sc_hd__o41ai_2
X_4722_ clkload6/A _4722_/D fanout380/X vssd1 vssd1 vccd1 vccd1 _4722_/Q sky130_fd_sc_hd__dfrtp_1
X_4653_ _4794_/CLK _4653_/D fanout375/X vssd1 vssd1 vccd1 vccd1 _4653_/Q sky130_fd_sc_hd__dfrtp_1
X_4584_ _4587_/CLK _4584_/D fanout408/X vssd1 vssd1 vccd1 vccd1 _4584_/Q sky130_fd_sc_hd__dfrtp_1
X_3604_ _4517_/Q _4626_/Q vssd1 vssd1 vccd1 vccd1 _3604_/X sky130_fd_sc_hd__and2_1
X_3535_ _3535_/A _3535_/B _3535_/C _3535_/D vssd1 vssd1 vccd1 vccd1 _3535_/Y sky130_fd_sc_hd__nand4_1
X_3466_ _4606_/Q _3504_/A2 _3477_/B1 _3784_/A1 vssd1 vssd1 vccd1 vccd1 _3466_/X sky130_fd_sc_hd__o211a_1
X_2417_ _4576_/Q hold47/A _2421_/S vssd1 vssd1 vccd1 vccd1 _2417_/X sky130_fd_sc_hd__mux2_1
XANTENNA_fanout298_A _4372_/A vssd1 vssd1 vccd1 vccd1 sky130_fd_sc_hd__diode_2
X_3397_ _3278_/X _3280_/X _3370_/D _3284_/D _3250_/X vssd1 vssd1 vccd1 vccd1 _3398_/B
+ sky130_fd_sc_hd__a41oi_4
X_2348_ hold24/X _2347_/X _2366_/S vssd1 vssd1 vccd1 vccd1 _4469_/D sky130_fd_sc_hd__mux2_1
XFILLER_57_514 vssd1 vssd1 vccd1 vccd1 sky130_fd_sc_hd__fill_1
XFILLER_84_344 vccd1 vssd1 vccd1 vssd1 sky130_ef_sc_hd__decap_12
X_2279_ _3875_/A0 _2310_/A1 _3981_/D vssd1 vssd1 vccd1 vccd1 _2279_/X sky130_fd_sc_hd__mux2_1
XFILLER_84_377 vssd1 vssd1 vccd1 vccd1 sky130_fd_sc_hd__decap_6
X_4018_ _4017_/D _4038_/A2 _4193_/B2 vssd1 vssd1 vccd1 vccd1 _4018_/Y sky130_fd_sc_hd__o21ai_1
XFILLER_44_208 vssd1 vssd1 vccd1 vccd1 sky130_fd_sc_hd__decap_8
XTAP_TAPCELL_ROW_27_428 vssd1 vccd1 sky130_fd_sc_hd__tapvpwrvgnd_1
XFILLER_37_271 vssd1 vssd1 vccd1 vccd1 sky130_fd_sc_hd__decap_6
XFILLER_25_444 vssd1 vssd1 vccd1 vccd1 sky130_fd_sc_hd__decap_4
XFILLER_40_436 vssd1 vssd1 vccd1 vccd1 sky130_fd_sc_hd__fill_1
XANTENNA__4000__A1 _4020_/A1 vssd1 vssd1 vccd1 vccd1 sky130_fd_sc_hd__diode_2
XFILLER_79_138 vssd1 vssd1 vccd1 vccd1 sky130_fd_sc_hd__decap_3
XFILLER_87_160 vssd1 vssd1 vccd1 vccd1 sky130_fd_sc_hd__decap_8
XFILLER_87_193 vssd1 vssd1 vccd1 vccd1 sky130_fd_sc_hd__decap_3
XANTENNA_input26_A s_axis_tdata[30] vssd1 vssd1 vccd1 vccd1 sky130_fd_sc_hd__diode_2
XANTENNA__4067__A1 _4083_/A1 vssd1 vssd1 vccd1 vccd1 sky130_fd_sc_hd__diode_2
XFILLER_16_433 vssd1 vssd1 vccd1 vccd1 sky130_fd_sc_hd__decap_4
XFILLER_28_293 vssd1 vssd1 vccd1 vccd1 sky130_fd_sc_hd__fill_1
XFILLER_16_477 vssd1 vssd1 vccd1 vccd1 sky130_fd_sc_hd__decap_4
XFILLER_31_469 vssd1 vssd1 vccd1 vccd1 sky130_fd_sc_hd__decap_6
XANTENNA__2351__S _2365_/S vssd1 vssd1 vccd1 vccd1 sky130_fd_sc_hd__diode_2
Xhold109 _4749_/Q vssd1 vssd1 vccd1 vccd1 hold109/X sky130_fd_sc_hd__dlygate4sd3_1
X_3320_ _4578_/Q _3333_/B vssd1 vssd1 vccd1 vccd1 _3322_/B sky130_fd_sc_hd__xor2_1
XFILLER_3_381 vssd1 vssd1 vccd1 vccd1 sky130_fd_sc_hd__decap_8
XTAP_TAPCELL_ROW_69_807 vssd1 vccd1 sky130_fd_sc_hd__tapvpwrvgnd_1
X_3251_ _3228_/Y _3406_/B _3286_/B _3249_/Y _3233_/Y vssd1 vssd1 vccd1 vccd1 _3251_/Y
+ sky130_fd_sc_hd__o221ai_2
X_3182_ _4568_/Q _4609_/Q vssd1 vssd1 vccd1 vccd1 _3481_/B sky130_fd_sc_hd__xor2_1
XFILLER_21_3 vccd1 vssd1 vccd1 vssd1 sky130_ef_sc_hd__decap_12
XTAP_TAPCELL_ROW_77_884 vssd1 vccd1 sky130_fd_sc_hd__tapvpwrvgnd_1
XFILLER_66_377 vssd1 vssd1 vccd1 vccd1 sky130_fd_sc_hd__decap_3
XFILLER_81_325 vssd1 vssd1 vccd1 vccd1 sky130_fd_sc_hd__decap_4
XTAP_TAPCELL_ROW_24_409 vssd1 vccd1 sky130_fd_sc_hd__tapvpwrvgnd_1
X_2966_ _2967_/C _2967_/D vssd1 vssd1 vccd1 vccd1 _2966_/Y sky130_fd_sc_hd__nand2_1
XTAP_TAPCELL_ROW_32_475 vssd1 vccd1 sky130_fd_sc_hd__tapvpwrvgnd_1
X_4705_ clkload3/A _4705_/D fanout376/X vssd1 vssd1 vccd1 vccd1 _4705_/Q sky130_fd_sc_hd__dfrtp_1
X_2897_ _2897_/A _2897_/B vssd1 vssd1 vccd1 vccd1 _3835_/A sky130_fd_sc_hd__xnor2_1
XANTENNA__2261__S _2270_/S vssd1 vssd1 vccd1 vccd1 sky130_fd_sc_hd__diode_2
X_4636_ _4640_/CLK _4636_/D fanout425/X vssd1 vssd1 vccd1 vccd1 _4636_/Q sky130_fd_sc_hd__dfrtp_1
X_4567_ _4609_/CLK _4567_/D fanout426/X vssd1 vssd1 vccd1 vccd1 _4567_/Q sky130_fd_sc_hd__dfrtp_1
X_4498_ _4612_/CLK _4498_/D fanout436/X vssd1 vssd1 vccd1 vccd1 hold15/A sky130_fd_sc_hd__dfrtp_1
X_3518_ _4574_/Q _3522_/A2 _3517_/X _3503_/X vssd1 vssd1 vccd1 vccd1 _4574_/D sky130_fd_sc_hd__a22o_1
X_3449_ _4603_/Q _3504_/A2 _3477_/B1 _3923_/A vssd1 vssd1 vccd1 vccd1 _3449_/X sky130_fd_sc_hd__o211a_1
XFILLER_76_119 vssd1 vssd1 vccd1 vccd1 sky130_fd_sc_hd__decap_8
XFILLER_72_347 vssd1 vssd1 vccd1 vccd1 sky130_fd_sc_hd__fill_1
XFILLER_13_458 vssd1 vssd1 vccd1 vccd1 sky130_fd_sc_hd__decap_6
XFILLER_40_233 vssd1 vssd1 vccd1 vccd1 sky130_fd_sc_hd__decap_6
XANTENNA__3980__A0 _4020_/A0 vssd1 vssd1 vccd1 vccd1 sky130_fd_sc_hd__diode_2
XFILLER_4_112 vccd1 vssd1 vccd1 vssd1 sky130_ef_sc_hd__decap_12
XFILLER_4_145 vccd1 vssd1 vccd1 vssd1 sky130_ef_sc_hd__decap_12
XFILLER_4_49 vccd1 vssd1 vccd1 vssd1 sky130_ef_sc_hd__decap_12
XFILLER_75_174 vssd1 vssd1 vccd1 vccd1 sky130_fd_sc_hd__fill_1
XTAP_TAPCELL_ROW_74_854 vssd1 vccd1 sky130_fd_sc_hd__tapvpwrvgnd_1
XFILLER_16_274 vssd1 vssd1 vccd1 vccd1 sky130_fd_sc_hd__decap_3
XFILLER_71_391 vssd1 vssd1 vccd1 vccd1 sky130_fd_sc_hd__fill_1
X_2820_ _2820_/A _4774_/Q _4759_/Q vssd1 vssd1 vccd1 vccd1 _2820_/X sky130_fd_sc_hd__and3_1
XANTENNA__4212__A1 _4273_/S vssd1 vssd1 vccd1 vccd1 sky130_fd_sc_hd__diode_2
X_2751_ _4727_/Q _2710_/B _2709_/A vssd1 vssd1 vccd1 vccd1 _2754_/A sky130_fd_sc_hd__a21o_1
XFILLER_8_473 vssd1 vssd1 vccd1 vccd1 sky130_fd_sc_hd__decap_3
XANTENNA__3971__A0 _3872_/X vssd1 vssd1 vccd1 vccd1 sky130_fd_sc_hd__diode_2
X_2682_ _2676_/Y _2682_/B _2682_/C vssd1 vssd1 vccd1 vccd1 _2682_/X sky130_fd_sc_hd__and3b_1
XFILLER_8_495 vssd1 vssd1 vccd1 vccd1 sky130_fd_sc_hd__decap_4
X_4421_ _4546_/CLK _4421_/D fanout417/X vssd1 vssd1 vccd1 vccd1 hold56/A sky130_fd_sc_hd__dfrtp_1
X_4352_ _4352_/A _4371_/B _4371_/C vssd1 vssd1 vccd1 vccd1 _4352_/X sky130_fd_sc_hd__and3_1
X_3303_ _3301_/D _3188_/A _3300_/X _3302_/C vssd1 vssd1 vccd1 vccd1 _3511_/B sky130_fd_sc_hd__o31ai_2
X_4283_ _4348_/A _4307_/A2 _4295_/B1 vssd1 vssd1 vccd1 vccd1 _4283_/Y sky130_fd_sc_hd__o21ai_1
Xfanout408 fanout414/X vssd1 vssd1 vccd1 vccd1 fanout408/X sky130_fd_sc_hd__clkbuf_4
Xfanout419 fanout422/X vssd1 vssd1 vccd1 vccd1 fanout419/X sky130_fd_sc_hd__buf_2
X_3234_ _4554_/Q _4595_/Q vssd1 vssd1 vccd1 vccd1 _3406_/B sky130_fd_sc_hd__nor2_1
XFILLER_39_333 vssd1 vssd1 vccd1 vccd1 sky130_fd_sc_hd__decap_3
X_3165_ _4571_/Q _4612_/Q vssd1 vssd1 vccd1 vccd1 _3166_/B sky130_fd_sc_hd__or2_1
XFILLER_66_141 vccd1 vssd1 vccd1 vssd1 sky130_ef_sc_hd__decap_12
X_3096_ _4785_/Q _4770_/Q vssd1 vssd1 vccd1 vccd1 _3130_/B sky130_fd_sc_hd__and2_1
XFILLER_81_122 vssd1 vssd1 vccd1 vccd1 sky130_fd_sc_hd__decap_4
XTAP_TAPCELL_ROW_37_523 vssd1 vccd1 sky130_fd_sc_hd__tapvpwrvgnd_1
XFILLER_39_388 vssd1 vssd1 vccd1 vccd1 sky130_fd_sc_hd__fill_2
XFILLER_54_358 vssd1 vssd1 vccd1 vccd1 sky130_fd_sc_hd__decap_6
XFILLER_81_199 vssd1 vssd1 vccd1 vccd1 sky130_fd_sc_hd__fill_1
XFILLER_22_233 vssd1 vssd1 vccd1 vccd1 sky130_fd_sc_hd__fill_1
XANTENNA__3876__A _4808_/Q vssd1 vssd1 vccd1 vccd1 sky130_fd_sc_hd__diode_2
X_3998_ _4064_/D _4022_/A2 _3999_/B2 vssd1 vssd1 vccd1 vccd1 _3998_/Y sky130_fd_sc_hd__o21ai_1
XFILLER_22_244 vssd1 vssd1 vccd1 vccd1 sky130_fd_sc_hd__decap_3
X_2949_ _2975_/A _2949_/B vssd1 vssd1 vccd1 vccd1 _2951_/C sky130_fd_sc_hd__nand2_1
XANTENNA__3962__B1 _4799_/Q vssd1 vssd1 vccd1 vccd1 sky130_fd_sc_hd__diode_2
XANTENNA_fanout216_X _3923_/A vssd1 vssd1 vccd1 vccd1 sky130_fd_sc_hd__diode_2
XANTENNA__4203__C _4203_/C vssd1 vssd1 vccd1 vccd1 sky130_fd_sc_hd__diode_2
X_4619_ _4669_/CLK _4619_/D fanout406/X vssd1 vssd1 vccd1 vccd1 _4619_/Q sky130_fd_sc_hd__dfrtp_2
XFILLER_1_104 vssd1 vssd1 vccd1 vccd1 sky130_fd_sc_hd__decap_8
XFILLER_1_137 vccd1 vssd1 vccd1 vssd1 sky130_ef_sc_hd__decap_12
XFILLER_57_163 vssd1 vssd1 vccd1 vccd1 sky130_fd_sc_hd__decap_4
XTAP_TAPCELL_ROW_71_824 vssd1 vccd1 sky130_fd_sc_hd__tapvpwrvgnd_1
XTAP_TAPCELL_ROW_0_181 vssd1 vccd1 sky130_fd_sc_hd__tapvpwrvgnd_1
XFILLER_60_306 vssd1 vssd1 vccd1 vccd1 sky130_fd_sc_hd__fill_2
XTAP_TAPCELL_ROW_0_192 vssd1 vccd1 sky130_fd_sc_hd__tapvpwrvgnd_1
XANTENNA__3953__B1 _4075_/S vssd1 vssd1 vccd1 vccd1 sky130_fd_sc_hd__diode_2
Xclkload29 _4668_/CLK vssd1 vssd1 vccd1 vccd1 clkload29/Y sky130_fd_sc_hd__clkinv_2
Xclkload18 _4744_/CLK vssd1 vssd1 vccd1 vccd1 clkload18/Y sky130_fd_sc_hd__clkinv_2
XTAP_TAPCELL_ROW_79_902 vssd1 vccd1 sky130_fd_sc_hd__tapvpwrvgnd_1
XANTENNA__3484__A2 _3522_/A2 vssd1 vssd1 vccd1 vccd1 sky130_fd_sc_hd__diode_2
XFILLER_76_472 vssd1 vssd1 vccd1 vccd1 sky130_fd_sc_hd__decap_4
X_3921_ _4264_/B2 _4344_/B _3920_/Y vssd1 vssd1 vccd1 vccd1 _4665_/D sky130_fd_sc_hd__a21oi_1
XANTENNA__3696__A _3741_/S vssd1 vssd1 vccd1 vccd1 sky130_fd_sc_hd__diode_2
X_3852_ _4644_/Q _3869_/S _3117_/A _3851_/Y vssd1 vssd1 vccd1 vccd1 _4644_/D sky130_fd_sc_hd__a22o_1
XTAP_TAPCELL_ROW_42_570 vssd1 vccd1 sky130_fd_sc_hd__tapvpwrvgnd_1
X_2803_ _2799_/X _2801_/Y _2872_/A vssd1 vssd1 vccd1 vccd1 _2806_/B sky130_fd_sc_hd__o21ai_1
X_3783_ _4612_/Q _3735_/S _3782_/Y _3781_/Y vssd1 vssd1 vccd1 vccd1 _4612_/D sky130_fd_sc_hd__a22o_1
XANTENNA__3944__A0 _3872_/X vssd1 vssd1 vccd1 vccd1 sky130_fd_sc_hd__diode_2
X_2734_ _2770_/A _4698_/Q _4466_/Q vssd1 vssd1 vccd1 vccd1 _2735_/B sky130_fd_sc_hd__nor3_1
X_2665_ _2664_/Y _4464_/Q _2716_/C vssd1 vssd1 vccd1 vccd1 _2716_/D sky130_fd_sc_hd__nand3b_1
X_4404_ _4231_/D input20/X _4408_/S vssd1 vssd1 vccd1 vccd1 _4813_/D sky130_fd_sc_hd__mux2_1
X_2596_ _2590_/A _2590_/B _2593_/A vssd1 vssd1 vccd1 vccd1 _2615_/A sky130_fd_sc_hd__a21oi_2
XANTENNA__4320__A _4320_/A vssd1 vssd1 vccd1 vccd1 sky130_fd_sc_hd__diode_2
XFILLER_5_81 vccd1 vssd1 vccd1 vssd1 sky130_ef_sc_hd__decap_12
Xfanout205 _2278_/Y vssd1 vssd1 vccd1 vccd1 _2341_/A0 sky130_fd_sc_hd__clkbuf_2
X_4335_ _4339_/A0 _4343_/A1 _4340_/A vssd1 vssd1 vccd1 vccd1 _4335_/X sky130_fd_sc_hd__mux2_1
Xfanout227 _3910_/X vssd1 vssd1 vccd1 vccd1 _4173_/A2 sky130_fd_sc_hd__clkbuf_4
Xfanout216 _4377_/C1 vssd1 vssd1 vccd1 vccd1 _3923_/A sky130_fd_sc_hd__buf_2
Xfanout238 _2271_/S vssd1 vssd1 vccd1 vccd1 _2272_/S sky130_fd_sc_hd__clkbuf_4
Xfanout249 _4328_/C vssd1 vssd1 vccd1 vccd1 _4371_/C sky130_fd_sc_hd__clkbuf_2
X_4266_ _4286_/A_N _4282_/B _4270_/C _4266_/D vssd1 vssd1 vccd1 vccd1 _4266_/X sky130_fd_sc_hd__and4b_1
XANTENNA_fanout280_A _4811_/Q vssd1 vssd1 vccd1 vccd1 sky130_fd_sc_hd__diode_2
X_4197_ _4196_/Y _4195_/X _4194_/X hold102/X _4209_/B2 vssd1 vssd1 vccd1 vccd1 _4741_/D
+ sky130_fd_sc_hd__o32a_1
X_3217_ _4562_/Q _4603_/Q _4602_/Q _4561_/Q vssd1 vssd1 vccd1 vccd1 _3217_/X sky130_fd_sc_hd__a22o_1
X_3148_ _3862_/A _3863_/A2 _3123_/B _3124_/B _3145_/A vssd1 vssd1 vccd1 vccd1 _3155_/A
+ sky130_fd_sc_hd__a32o_1
XANTENNA_fanout378_A fanout379/X vssd1 vssd1 vccd1 vccd1 sky130_fd_sc_hd__diode_2
XFILLER_82_475 vssd1 vssd1 vccd1 vccd1 sky130_fd_sc_hd__fill_1
X_3079_ _3862_/A _3863_/A2 _3046_/B _3053_/A _3145_/A vssd1 vssd1 vccd1 vccd1 _3089_/A
+ sky130_fd_sc_hd__a32o_1
XANTENNA_fanout166_X _4210_/A1 vssd1 vssd1 vccd1 vccd1 sky130_fd_sc_hd__diode_2
XANTENNA_fanout333_X _4332_/A vssd1 vssd1 vccd1 vccd1 sky130_fd_sc_hd__diode_2
XFILLER_24_79 vssd1 vssd1 vccd1 vccd1 sky130_fd_sc_hd__fill_1
XANTENNA__3935__A0 _3872_/X vssd1 vssd1 vccd1 vccd1 sky130_fd_sc_hd__diode_2
XFILLER_45_111 vssd1 vssd1 vccd1 vccd1 sky130_fd_sc_hd__fill_1
XTAP_TAPCELL_ROW_48_618 vssd1 vccd1 sky130_fd_sc_hd__tapvpwrvgnd_1
XFILLER_58_472 vssd1 vssd1 vccd1 vccd1 sky130_fd_sc_hd__decap_4
XANTENNA__3466__A2 _3504_/A2 vssd1 vssd1 vccd1 vccd1 sky130_fd_sc_hd__diode_2
XFILLER_45_177 vssd1 vssd1 vccd1 vccd1 sky130_fd_sc_hd__fill_1
XTAP_TAPCELL_ROW_56_695 vssd1 vccd1 sky130_fd_sc_hd__tapvpwrvgnd_1
XFILLER_60_114 vssd1 vssd1 vccd1 vccd1 sky130_fd_sc_hd__decap_3
XFILLER_60_125 vssd1 vssd1 vccd1 vccd1 sky130_fd_sc_hd__decap_4
XANTENNA__4124__B _4136_/B vssd1 vssd1 vccd1 vccd1 sky130_fd_sc_hd__diode_2
XTAP_TAPCELL_ROW_11_286 vssd1 vccd1 sky130_fd_sc_hd__tapvpwrvgnd_1
X_2450_ _4512_/Q _3806_/A2 _2449_/Y vssd1 vssd1 vccd1 vccd1 _4512_/D sky130_fd_sc_hd__o21a_1
X_2381_ _4558_/Q hold64/A _2381_/S vssd1 vssd1 vccd1 vccd1 _2381_/X sky130_fd_sc_hd__mux2_1
X_4120_ _4199_/D _4136_/B _4120_/C _4120_/D vssd1 vssd1 vccd1 vccd1 _4120_/X sky130_fd_sc_hd__and4b_1
X_4051_ _4099_/A0 _4083_/A1 _4119_/S vssd1 vssd1 vccd1 vccd1 _4051_/X sky130_fd_sc_hd__mux2_1
Xinput5 s_axis_tdata[11] vssd1 vssd1 vccd1 vccd1 input5/X sky130_fd_sc_hd__clkbuf_1
X_3002_ _4764_/Q _4779_/Q _2975_/A _2978_/B vssd1 vssd1 vccd1 vccd1 _3009_/A sky130_fd_sc_hd__a31o_1
XFILLER_64_475 vssd1 vssd1 vccd1 vccd1 sky130_fd_sc_hd__fill_1
XTAP_TAPCELL_ROW_19_364 vssd1 vccd1 sky130_fd_sc_hd__tapvpwrvgnd_1
XFILLER_36_199 vssd1 vssd1 vccd1 vccd1 sky130_fd_sc_hd__decap_4
X_3904_ _4001_/B _4001_/C _4056_/D vssd1 vssd1 vccd1 vccd1 _3904_/X sky130_fd_sc_hd__or3b_1
X_3835_ _3835_/A _3835_/B vssd1 vssd1 vccd1 vccd1 _3835_/Y sky130_fd_sc_hd__nand2_1
X_3766_ _4644_/Q _4535_/Q vssd1 vssd1 vccd1 vccd1 _3767_/D sky130_fd_sc_hd__nand2b_1
XANTENNA_fanout126_A _2274_/Y vssd1 vssd1 vccd1 vccd1 sky130_fd_sc_hd__diode_2
X_2717_ _2717_/A _2717_/B _2717_/C vssd1 vssd1 vccd1 vccd1 _2717_/Y sky130_fd_sc_hd__nand3_2
X_3697_ _4602_/Q _3741_/S _3696_/Y _3709_/A vssd1 vssd1 vccd1 vccd1 _4602_/D sky130_fd_sc_hd__a22o_1
X_2648_ _2648_/A _2648_/B _2648_/C vssd1 vssd1 vccd1 vccd1 _2649_/B sky130_fd_sc_hd__nand3_1
X_2579_ _2617_/D _2578_/A _4663_/Q vssd1 vssd1 vccd1 vccd1 _2580_/B sky130_fd_sc_hd__a21oi_2
X_4318_ _4317_/Y _4316_/X _4315_/X hold106/X _4334_/A2 vssd1 vssd1 vccd1 vccd1 _4772_/D
+ sky130_fd_sc_hd__o32a_1
XFILLER_59_225 vccd1 vssd1 vccd1 vssd1 sky130_ef_sc_hd__decap_12
X_4249_ _4281_/A0 _4281_/A1 _4320_/A vssd1 vssd1 vccd1 vccd1 _4249_/X sky130_fd_sc_hd__mux2_1
XTAP_TAPCELL_ROW_2_210 vssd1 vccd1 sky130_fd_sc_hd__tapvpwrvgnd_1
XFILLER_82_272 vssd1 vssd1 vccd1 vccd1 sky130_fd_sc_hd__decap_3
XFILLER_82_250 vssd1 vssd1 vccd1 vccd1 sky130_fd_sc_hd__fill_2
XFILLER_70_456 vccd1 vssd1 vccd1 vssd1 sky130_ef_sc_hd__decap_12
XFILLER_35_89 vssd1 vssd1 vccd1 vccd1 sky130_fd_sc_hd__fill_1
XTAP_TAPCELL_ROW_53_665 vssd1 vccd1 sky130_fd_sc_hd__tapvpwrvgnd_1
XANTENNA__3620__A2 _3735_/S vssd1 vssd1 vccd1 vccd1 sky130_fd_sc_hd__diode_2
XFILLER_7_505 vssd1 vssd1 vccd1 vccd1 sky130_fd_sc_hd__fill_1
XANTENNA__4333__B1 _4376_/A2 vssd1 vssd1 vccd1 vccd1 sky130_fd_sc_hd__diode_2
XFILLER_76_85 vccd1 vssd1 vccd1 vssd1 sky130_ef_sc_hd__decap_12
XANTENNA__3439__A2 _3504_/A2 vssd1 vssd1 vccd1 vccd1 sky130_fd_sc_hd__diode_2
XFILLER_58_291 vssd1 vssd1 vccd1 vccd1 sky130_fd_sc_hd__decap_6
XFILLER_46_475 vssd1 vssd1 vccd1 vccd1 sky130_fd_sc_hd__fill_1
XANTENNA__2354__S _2366_/S vssd1 vssd1 vccd1 vccd1 sky130_fd_sc_hd__diode_2
XTAP_TAPCELL_ROW_16_334 vssd1 vccd1 sky130_fd_sc_hd__tapvpwrvgnd_1
X_3620_ _3619_/X _3735_/S _3618_/Y _3615_/X vssd1 vssd1 vccd1 vccd1 _4593_/D sky130_fd_sc_hd__o31a_1
X_3551_ _4510_/Q _4618_/Q vssd1 vssd1 vccd1 vccd1 _3551_/X sky130_fd_sc_hd__and2_1
X_2502_ _2502_/A _2502_/B vssd1 vssd1 vccd1 vccd1 _3811_/A sky130_fd_sc_hd__xnor2_1
X_3482_ _3507_/A _3480_/X _3481_/Y _3536_/B1 vssd1 vssd1 vccd1 vccd1 _3482_/X sky130_fd_sc_hd__a31o_1
XFILLER_51_3 vssd1 vssd1 vccd1 vccd1 sky130_fd_sc_hd__fill_1
XFILLER_69_501 vssd1 vssd1 vccd1 vccd1 sky130_fd_sc_hd__fill_1
X_2433_ _4671_/Q _4452_/Q vssd1 vssd1 vccd1 vccd1 _2434_/B sky130_fd_sc_hd__nor2_1
X_2364_ hold13/X _2363_/X _2366_/S vssd1 vssd1 vccd1 vccd1 _4477_/D sky130_fd_sc_hd__mux2_1
X_4103_ _4103_/A0 _4103_/A1 _4803_/Q vssd1 vssd1 vccd1 vccd1 _4103_/X sky130_fd_sc_hd__mux2_1
X_2295_ _3935_/S _2295_/B _2295_/C vssd1 vssd1 vccd1 vccd1 _2295_/X sky130_fd_sc_hd__and3_1
XANTENNA__4029__B _4037_/B vssd1 vssd1 vccd1 vccd1 sky130_fd_sc_hd__diode_2
X_4034_ _4033_/D _4038_/A2 _4039_/B2 vssd1 vssd1 vccd1 vccd1 _4034_/Y sky130_fd_sc_hd__o21ai_1
XFILLER_64_250 vssd1 vssd1 vccd1 vccd1 sky130_fd_sc_hd__fill_2
XANTENNA__2264__S _2270_/S vssd1 vssd1 vccd1 vccd1 sky130_fd_sc_hd__diode_2
XTAP_TAPCELL_ROW_50_635 vssd1 vccd1 sky130_fd_sc_hd__tapvpwrvgnd_1
XANTENNA_fanout410_A fanout414/X vssd1 vssd1 vccd1 vccd1 sky130_fd_sc_hd__diode_2
X_3818_ hold206/X _3830_/A2 _3817_/Y vssd1 vssd1 vccd1 vccd1 _4627_/D sky130_fd_sc_hd__a21o_1
X_4798_ _4815_/CLK _4798_/D fanout394/X vssd1 vssd1 vccd1 vccd1 _4798_/Q sky130_fd_sc_hd__dfrtp_2
XFILLER_21_25 vssd1 vssd1 vccd1 vccd1 sky130_fd_sc_hd__fill_1
XANTENNA_fanout129_X _4376_/A2 vssd1 vssd1 vccd1 vccd1 sky130_fd_sc_hd__diode_2
X_3749_ _3748_/B _3748_/A _3784_/A1 _3543_/B vssd1 vssd1 vccd1 vccd1 _3749_/X sky130_fd_sc_hd__o211a_1
XFILLER_21_69 vssd1 vssd1 vccd1 vccd1 sky130_fd_sc_hd__fill_1
XANTENNA__4211__C _4273_/S vssd1 vssd1 vccd1 vccd1 sky130_fd_sc_hd__diode_2
XTAP_TAPCELL_ROW_58_713 vssd1 vccd1 sky130_fd_sc_hd__tapvpwrvgnd_1
XFILLER_55_261 vssd1 vssd1 vccd1 vccd1 sky130_fd_sc_hd__fill_1
XFILLER_70_253 vccd1 vssd1 vccd1 vssd1 sky130_ef_sc_hd__decap_12
XFILLER_70_242 vssd1 vssd1 vccd1 vccd1 sky130_fd_sc_hd__decap_8
XFILLER_15_169 vssd1 vssd1 vccd1 vccd1 sky130_fd_sc_hd__decap_6
XFILLER_15_136 vssd1 vssd1 vccd1 vccd1 sky130_fd_sc_hd__decap_3
XANTENNA_clkbuf_2_0__f_clk_A clkbuf_0_clk/X vssd1 vssd1 vccd1 vccd1 sky130_fd_sc_hd__diode_2
XFILLER_70_275 vccd1 vssd1 vccd1 vssd1 sky130_ef_sc_hd__decap_12
XTAP_TAPCELL_ROW_13_304 vssd1 vccd1 sky130_fd_sc_hd__tapvpwrvgnd_1
XANTENNA_clkbuf_leaf_16_clk_A clkload1/A vssd1 vssd1 vccd1 vccd1 sky130_fd_sc_hd__diode_2
XFILLER_62_87 vssd1 vssd1 vccd1 vccd1 sky130_fd_sc_hd__fill_1
XFILLER_7_335 vssd1 vssd1 vccd1 vccd1 sky130_fd_sc_hd__fill_1
XTAP_TAPCELL_ROW_21_381 vssd1 vccd1 sky130_fd_sc_hd__tapvpwrvgnd_1
XFILLER_78_353 vssd1 vssd1 vccd1 vccd1 sky130_fd_sc_hd__decap_8
XANTENNA__2349__S _2365_/S vssd1 vssd1 vccd1 vccd1 sky130_fd_sc_hd__diode_2
XANTENNA__4085__A2 _4105_/A2 vssd1 vssd1 vccd1 vccd1 sky130_fd_sc_hd__diode_2
X_2982_ _2940_/A _2942_/A _2980_/X _2981_/Y vssd1 vssd1 vccd1 vccd1 _3000_/B sky130_fd_sc_hd__o22ai_2
X_4721_ clkload3/A _4721_/D fanout376/X vssd1 vssd1 vccd1 vccd1 _4721_/Q sky130_fd_sc_hd__dfrtp_1
X_4652_ _4687_/CLK _4652_/D fanout383/X vssd1 vssd1 vccd1 vccd1 _4652_/Q sky130_fd_sc_hd__dfrtp_1
Xinput30 s_axis_tdata[5] vssd1 vssd1 vccd1 vccd1 input30/X sky130_fd_sc_hd__clkbuf_1
X_3603_ _3602_/Y hold197/X _3603_/S vssd1 vssd1 vccd1 vccd1 _4591_/D sky130_fd_sc_hd__mux2_1
X_4583_ _4587_/CLK _4583_/D fanout408/X vssd1 vssd1 vccd1 vccd1 _4583_/Q sky130_fd_sc_hd__dfrtp_1
X_3534_ _4578_/Q _3534_/A2 _3533_/X _3503_/X vssd1 vssd1 vccd1 vccd1 _4578_/D sky130_fd_sc_hd__a22o_1
X_3465_ _3536_/A2 _3463_/Y _3464_/X _3536_/B1 vssd1 vssd1 vccd1 vccd1 _3465_/X sky130_fd_sc_hd__a31o_1
X_2416_ hold12/X _2415_/X _2420_/S vssd1 vssd1 vccd1 vccd1 _4503_/D sky130_fd_sc_hd__mux2_1
X_3396_ _4552_/Q _3396_/A2 _3394_/X _3395_/X vssd1 vssd1 vccd1 vccd1 _4552_/D sky130_fd_sc_hd__a22o_1
XANTENNA__2259__S _2270_/S vssd1 vssd1 vccd1 vccd1 sky130_fd_sc_hd__diode_2
X_2347_ _4541_/Q hold61/A _2365_/S vssd1 vssd1 vccd1 vccd1 _2347_/X sky130_fd_sc_hd__mux2_1
XFILLER_84_334 vssd1 vssd1 vccd1 vccd1 sky130_fd_sc_hd__fill_1
XFILLER_69_397 vccd1 vssd1 vccd1 vssd1 sky130_ef_sc_hd__decap_12
X_2278_ _2340_/B _2295_/C _2295_/B vssd1 vssd1 vccd1 vccd1 _2278_/Y sky130_fd_sc_hd__nor3_1
XFILLER_84_356 vssd1 vssd1 vccd1 vccd1 sky130_fd_sc_hd__decap_8
XFILLER_72_518 vssd1 vssd1 vccd1 vccd1 sky130_fd_sc_hd__fill_1
X_4017_ _4100_/C _4037_/B _4037_/C _4017_/D vssd1 vssd1 vccd1 vccd1 _4017_/X sky130_fd_sc_hd__and4b_1
XANTENNA_fanout360_A _3794_/A0 vssd1 vssd1 vccd1 vccd1 sky130_fd_sc_hd__diode_2
XFILLER_25_412 vssd1 vssd1 vccd1 vccd1 sky130_fd_sc_hd__fill_2
XFILLER_25_434 vssd1 vssd1 vccd1 vccd1 sky130_fd_sc_hd__decap_4
XTAP_TAPCELL_ROW_27_429 vssd1 vccd1 sky130_fd_sc_hd__tapvpwrvgnd_1
XANTENNA_fanout246_X _2421_/S vssd1 vssd1 vccd1 vccd1 sky130_fd_sc_hd__diode_2
XTAP_TAPCELL_ROW_63_760 vssd1 vccd1 sky130_fd_sc_hd__tapvpwrvgnd_1
XFILLER_40_404 vssd1 vssd1 vccd1 vccd1 sky130_fd_sc_hd__fill_2
XFILLER_52_264 vccd1 vssd1 vccd1 vssd1 sky130_ef_sc_hd__decap_12
XFILLER_4_349 vssd1 vssd1 vccd1 vccd1 sky130_fd_sc_hd__fill_1
XFILLER_79_117 vssd1 vssd1 vccd1 vccd1 sky130_fd_sc_hd__fill_1
XFILLER_63_518 vssd1 vssd1 vccd1 vccd1 sky130_fd_sc_hd__fill_1
XFILLER_63_507 vssd1 vssd1 vccd1 vccd1 sky130_fd_sc_hd__fill_1
XANTENNA_input19_A s_axis_tdata[24] vssd1 vssd1 vccd1 vccd1 sky130_fd_sc_hd__diode_2
XFILLER_16_401 vssd1 vssd1 vccd1 vccd1 sky130_fd_sc_hd__decap_8
XFILLER_43_242 vssd1 vssd1 vccd1 vccd1 sky130_fd_sc_hd__decap_8
XFILLER_73_97 vssd1 vssd1 vccd1 vccd1 sky130_fd_sc_hd__fill_1
XFILLER_43_253 vssd1 vssd1 vccd1 vccd1 sky130_fd_sc_hd__decap_3
XANTENNA__4116__C _4136_/B vssd1 vssd1 vccd1 vccd1 sky130_fd_sc_hd__diode_2
XANTENNA__4132__B _4136_/B vssd1 vssd1 vccd1 vccd1 sky130_fd_sc_hd__diode_2
XANTENNA__2868__A _4702_/Q vssd1 vssd1 vccd1 vccd1 sky130_fd_sc_hd__diode_2
XTAP_TAPCELL_ROW_69_808 vssd1 vccd1 sky130_fd_sc_hd__tapvpwrvgnd_1
XFILLER_3_393 vssd1 vssd1 vccd1 vccd1 sky130_fd_sc_hd__decap_4
X_3250_ _3393_/A _3284_/B _3246_/Y _3248_/X vssd1 vssd1 vccd1 vccd1 _3250_/X sky130_fd_sc_hd__a31o_1
X_3181_ _3475_/A _3475_/B vssd1 vssd1 vccd1 vccd1 _3474_/A sky130_fd_sc_hd__nor2_1
XFILLER_66_323 vssd1 vssd1 vccd1 vccd1 sky130_fd_sc_hd__fill_1
XFILLER_81_337 vccd1 vssd1 vccd1 vssd1 sky130_ef_sc_hd__decap_12
XFILLER_81_315 vssd1 vssd1 vccd1 vccd1 sky130_fd_sc_hd__decap_6
XTAP_TAPCELL_ROW_77_885 vssd1 vccd1 sky130_fd_sc_hd__tapvpwrvgnd_1
XFILLER_34_253 vssd1 vssd1 vccd1 vccd1 sky130_fd_sc_hd__fill_2
XTAP_TAPCELL_ROW_60_730 vssd1 vccd1 sky130_fd_sc_hd__tapvpwrvgnd_1
X_2965_ _2964_/C _2964_/A _2964_/B vssd1 vssd1 vccd1 vccd1 _2967_/D sky130_fd_sc_hd__o21ai_1
X_4704_ clkload3/A _4704_/D fanout375/X vssd1 vssd1 vccd1 vccd1 _4704_/Q sky130_fd_sc_hd__dfrtp_2
XTAP_TAPCELL_ROW_32_476 vssd1 vccd1 sky130_fd_sc_hd__tapvpwrvgnd_1
X_2896_ _2896_/A _2896_/B vssd1 vssd1 vccd1 vccd1 _2897_/B sky130_fd_sc_hd__xor2_1
X_4635_ _4635_/CLK _4635_/D fanout425/X vssd1 vssd1 vccd1 vccd1 _4635_/Q sky130_fd_sc_hd__dfrtp_1
X_4566_ _4605_/CLK _4566_/D fanout435/X vssd1 vssd1 vccd1 vccd1 _4566_/Q sky130_fd_sc_hd__dfrtp_1
X_3517_ _3516_/X _3507_/A _3525_/B1 vssd1 vssd1 vccd1 vccd1 _3517_/X sky130_fd_sc_hd__a21o_1
X_4497_ _4647_/CLK _4497_/D fanout429/X vssd1 vssd1 vccd1 vccd1 hold59/A sky130_fd_sc_hd__dfrtp_1
X_3448_ _3460_/A1 _3447_/X _3460_/B1 vssd1 vssd1 vccd1 vccd1 _3448_/X sky130_fd_sc_hd__a21o_1
X_3379_ _4549_/Q _3396_/A2 _3377_/X _3378_/X vssd1 vssd1 vccd1 vccd1 _4549_/D sky130_fd_sc_hd__a22o_1
XFILLER_84_120 vssd1 vssd1 vccd1 vccd1 sky130_fd_sc_hd__decap_3
XANTENNA__4049__A2 _4081_/A2 vssd1 vssd1 vccd1 vccd1 sky130_fd_sc_hd__diode_2
XFILLER_45_518 vssd1 vssd1 vccd1 vccd1 sky130_fd_sc_hd__fill_1
XFILLER_84_197 vssd1 vssd1 vccd1 vccd1 sky130_fd_sc_hd__fill_2
XFILLER_72_326 vssd1 vssd1 vccd1 vccd1 sky130_fd_sc_hd__fill_1
XFILLER_27_57 vccd1 vssd1 vccd1 vssd1 sky130_ef_sc_hd__decap_12
XFILLER_43_23 vssd1 vssd1 vccd1 vccd1 sky130_fd_sc_hd__fill_1
XANTENNA__3980__A1 _4020_/A1 vssd1 vssd1 vccd1 vccd1 sky130_fd_sc_hd__diode_2
XFILLER_4_124 vssd1 vssd1 vccd1 vccd1 sky130_fd_sc_hd__fill_1
XFILLER_4_157 vssd1 vssd1 vccd1 vccd1 sky130_fd_sc_hd__decap_6
XFILLER_68_42 vssd1 vssd1 vccd1 vccd1 sky130_fd_sc_hd__decap_3
XFILLER_84_41 vccd1 vssd1 vccd1 vssd1 sky130_ef_sc_hd__decap_12
XFILLER_75_142 vssd1 vssd1 vccd1 vccd1 sky130_fd_sc_hd__fill_1
XFILLER_75_131 vssd1 vssd1 vccd1 vccd1 sky130_fd_sc_hd__fill_1
XFILLER_75_164 vssd1 vssd1 vccd1 vccd1 sky130_fd_sc_hd__decap_4
XFILLER_84_96 vssd1 vssd1 vccd1 vccd1 sky130_fd_sc_hd__fill_1
XTAP_TAPCELL_ROW_74_855 vssd1 vccd1 sky130_fd_sc_hd__tapvpwrvgnd_1
XANTENNA__2870__B _4702_/Q vssd1 vssd1 vccd1 vccd1 sky130_fd_sc_hd__diode_2
XFILLER_31_256 vssd1 vssd1 vccd1 vccd1 sky130_fd_sc_hd__fill_1
XANTENNA__4212__A2 _4212_/A2 vssd1 vssd1 vccd1 vccd1 sky130_fd_sc_hd__diode_2
X_2750_ _2711_/A _2711_/B _2706_/B vssd1 vssd1 vccd1 vccd1 _2758_/A sky130_fd_sc_hd__o21ai_1
XANTENNA__3971__A1 _3971_/A1 vssd1 vssd1 vccd1 vccd1 sky130_fd_sc_hd__diode_2
X_2681_ _4725_/Q _2637_/B _2682_/B _2682_/C _2636_/A vssd1 vssd1 vccd1 vccd1 _2681_/Y
+ sky130_fd_sc_hd__a221oi_2
XFILLER_8_485 vssd1 vssd1 vccd1 vccd1 sky130_fd_sc_hd__fill_1
X_4420_ _4549_/CLK _4420_/D fanout415/X vssd1 vssd1 vccd1 vccd1 hold31/A sky130_fd_sc_hd__dfrtp_1
X_4351_ _4374_/A0 _4374_/A1 _4356_/A vssd1 vssd1 vccd1 vccd1 _4351_/X sky130_fd_sc_hd__mux2_1
XANTENNA__4289__S _4360_/A vssd1 vssd1 vccd1 vccd1 sky130_fd_sc_hd__diode_2
X_3302_ _3302_/A _3302_/B _3302_/C vssd1 vssd1 vccd1 vccd1 _3511_/A sky130_fd_sc_hd__nand3_1
X_4282_ _4286_/A_N _4282_/B _4302_/C _4348_/A vssd1 vssd1 vccd1 vccd1 _4282_/X sky130_fd_sc_hd__and4b_1
Xfanout409 fanout414/X vssd1 vssd1 vccd1 vccd1 fanout409/X sky130_fd_sc_hd__clkbuf_2
XFILLER_86_429 vssd1 vssd1 vccd1 vccd1 sky130_fd_sc_hd__decap_3
X_3233_ _4554_/Q _4595_/Q vssd1 vssd1 vccd1 vccd1 _3233_/Y sky130_fd_sc_hd__nand2_1
X_3164_ _4571_/Q _4612_/Q vssd1 vssd1 vccd1 vccd1 _3164_/Y sky130_fd_sc_hd__nor2_1
XFILLER_66_153 vssd1 vssd1 vccd1 vccd1 sky130_fd_sc_hd__decap_8
X_3095_ _4535_/Q _3157_/A2 _3078_/X _3094_/Y vssd1 vssd1 vccd1 vccd1 _4535_/D sky130_fd_sc_hd__o22a_1
XTAP_TAPCELL_ROW_37_524 vssd1 vccd1 sky130_fd_sc_hd__tapvpwrvgnd_1
XFILLER_54_304 vssd1 vssd1 vccd1 vccd1 sky130_fd_sc_hd__decap_4
XFILLER_54_315 vssd1 vssd1 vccd1 vccd1 sky130_fd_sc_hd__decap_4
XFILLER_66_197 vssd1 vssd1 vccd1 vccd1 sky130_fd_sc_hd__decap_4
XANTENNA__4037__B _4037_/B vssd1 vssd1 vccd1 vccd1 sky130_fd_sc_hd__diode_2
XANTENNA__3876__B _4037_/C vssd1 vssd1 vccd1 vccd1 sky130_fd_sc_hd__diode_2
XTAP_TAPCELL_ROW_45_590 vssd1 vccd1 sky130_fd_sc_hd__tapvpwrvgnd_1
X_3997_ _4064_/C _4001_/B _4001_/C _4064_/D vssd1 vssd1 vccd1 vccd1 _3997_/X sky130_fd_sc_hd__and4b_1
X_2948_ _4763_/Q _4778_/Q _2975_/A vssd1 vssd1 vccd1 vccd1 _2951_/B sky130_fd_sc_hd__a21o_1
XFILLER_13_59 vssd1 vssd1 vccd1 vccd1 sky130_fd_sc_hd__decap_8
X_4618_ _4669_/CLK _4618_/D fanout406/X vssd1 vssd1 vccd1 vccd1 _4618_/Q sky130_fd_sc_hd__dfrtp_2
XANTENNA_fanout111_X _3828_/A2 vssd1 vssd1 vccd1 vccd1 sky130_fd_sc_hd__diode_2
XANTENNA__4203__D _4239_/D vssd1 vssd1 vccd1 vccd1 sky130_fd_sc_hd__diode_2
X_2879_ _4747_/Q _4717_/Q vssd1 vssd1 vccd1 vccd1 _2880_/A sky130_fd_sc_hd__nor2_1
XANTENNA_fanout209_X _3946_/A2 vssd1 vssd1 vccd1 vccd1 sky130_fd_sc_hd__diode_2
X_4549_ _4549_/CLK _4549_/D fanout416/X vssd1 vssd1 vccd1 vccd1 _4549_/Q sky130_fd_sc_hd__dfrtp_4
XFILLER_1_149 vssd1 vssd1 vccd1 vccd1 sky130_fd_sc_hd__decap_8
XFILLER_38_23 vssd1 vssd1 vccd1 vccd1 sky130_fd_sc_hd__fill_1
XFILLER_72_101 vssd1 vssd1 vccd1 vccd1 sky130_fd_sc_hd__fill_1
XFILLER_45_315 vssd1 vssd1 vccd1 vccd1 sky130_fd_sc_hd__fill_1
XFILLER_57_197 vssd1 vssd1 vccd1 vccd1 sky130_fd_sc_hd__fill_2
XTAP_TAPCELL_ROW_71_825 vssd1 vccd1 sky130_fd_sc_hd__tapvpwrvgnd_1
XFILLER_54_33 vssd1 vssd1 vccd1 vccd1 sky130_fd_sc_hd__fill_1
XFILLER_13_201 vssd1 vssd1 vccd1 vccd1 sky130_fd_sc_hd__decap_4
XTAP_TAPCELL_ROW_0_182 vssd1 vccd1 sky130_fd_sc_hd__tapvpwrvgnd_1
XTAP_TAPCELL_ROW_0_193 vssd1 vccd1 sky130_fd_sc_hd__tapvpwrvgnd_1
XANTENNA__3953__A1 _3873_/Y vssd1 vssd1 vccd1 vccd1 sky130_fd_sc_hd__diode_2
XANTENNA__4191__A_N _4258_/C vssd1 vssd1 vccd1 vccd1 sky130_fd_sc_hd__diode_2
Xclkload19 _4745_/CLK vssd1 vssd1 vccd1 vccd1 clkload19/Y sky130_fd_sc_hd__bufinv_16
XTAP_TAPCELL_ROW_79_903 vssd1 vccd1 sky130_fd_sc_hd__tapvpwrvgnd_1
XFILLER_68_418 vssd1 vssd1 vccd1 vccd1 sky130_fd_sc_hd__fill_2
XTAP_TAPCELL_ROW_8_260 vssd1 vccd1 sky130_fd_sc_hd__tapvpwrvgnd_1
XANTENNA__3741__S _3741_/S vssd1 vssd1 vccd1 vccd1 sky130_fd_sc_hd__diode_2
XTAP_TAPCELL_ROW_87_980 vssd1 vccd1 sky130_fd_sc_hd__tapvpwrvgnd_1
XANTENNA__2357__S _2365_/S vssd1 vssd1 vccd1 vccd1 sky130_fd_sc_hd__diode_2
XFILLER_36_304 vssd1 vssd1 vccd1 vccd1 sky130_fd_sc_hd__fill_1
X_3920_ _4377_/C1 _4377_/B1 hold130/X vssd1 vssd1 vccd1 vccd1 _3920_/Y sky130_fd_sc_hd__a21oi_1
X_3851_ _3103_/X _3115_/Y _3114_/Y vssd1 vssd1 vccd1 vccd1 _3851_/Y sky130_fd_sc_hd__o21ai_1
X_3782_ _3777_/Y _3780_/Y _3741_/S vssd1 vssd1 vccd1 vccd1 _3782_/Y sky130_fd_sc_hd__a21oi_1
XTAP_TAPCELL_ROW_42_571 vssd1 vccd1 sky130_fd_sc_hd__tapvpwrvgnd_1
X_2802_ _2801_/Y _4468_/Q _2802_/C vssd1 vssd1 vccd1 vccd1 _2806_/A sky130_fd_sc_hd__nand3b_1
XANTENNA__3944__A1 _3971_/A1 vssd1 vssd1 vccd1 vccd1 sky130_fd_sc_hd__diode_2
X_2733_ _2785_/B _2785_/C vssd1 vssd1 vccd1 vccd1 _2786_/C sky130_fd_sc_hd__nand2_1
X_2664_ _4696_/Q _4683_/Q vssd1 vssd1 vccd1 vccd1 _2664_/Y sky130_fd_sc_hd__nor2_1
X_4403_ _4172_/B input19/X _4408_/S vssd1 vssd1 vccd1 vccd1 _4812_/D sky130_fd_sc_hd__mux2_1
X_2595_ _4519_/Q _3870_/B1 _2583_/Y _2594_/Y vssd1 vssd1 vccd1 vccd1 _4519_/D sky130_fd_sc_hd__o22a_1
XANTENNA__4320__B _4328_/B vssd1 vssd1 vccd1 vccd1 sky130_fd_sc_hd__diode_2
XANTENNA__4558__RESET_B fanout423/X vssd1 vssd1 vccd1 vccd1 sky130_fd_sc_hd__diode_2
X_4334_ hold160/X _4334_/A2 _4331_/X _4333_/X vssd1 vssd1 vccd1 vccd1 _4776_/D sky130_fd_sc_hd__o22a_1
Xfanout206 _2277_/Y vssd1 vssd1 vccd1 vccd1 _2310_/A1 sky130_fd_sc_hd__buf_2
XFILLER_5_93 vccd1 vssd1 vccd1 vssd1 sky130_ef_sc_hd__decap_12
Xfanout228 _4081_/A2 vssd1 vssd1 vccd1 vccd1 _4105_/A2 sky130_fd_sc_hd__clkbuf_4
Xfanout217 _3543_/A vssd1 vssd1 vccd1 vccd1 _3784_/A1 sky130_fd_sc_hd__buf_2
Xfanout239 _2271_/S vssd1 vssd1 vccd1 vccd1 _2270_/S sky130_fd_sc_hd__clkbuf_4
XANTENNA__4121__A1 _4120_/D vssd1 vssd1 vccd1 vccd1 sky130_fd_sc_hd__diode_2
X_4265_ _4281_/A0 _4281_/A1 _4336_/A vssd1 vssd1 vccd1 vccd1 _4265_/X sky130_fd_sc_hd__mux2_1
XFILLER_86_259 vssd1 vssd1 vccd1 vccd1 sky130_fd_sc_hd__fill_1
X_4196_ _4323_/S _4212_/A2 _4209_/B2 vssd1 vssd1 vccd1 vccd1 _4196_/Y sky130_fd_sc_hd__o21ai_1
X_3216_ _4564_/Q _4605_/Q _3215_/X _4563_/Q vssd1 vssd1 vccd1 vccd1 _3216_/X sky130_fd_sc_hd__a22o_1
X_3147_ _3147_/A _3147_/B vssd1 vssd1 vccd1 vccd1 _3147_/X sky130_fd_sc_hd__xor2_1
XANTENNA__2267__S _2271_/S vssd1 vssd1 vccd1 vccd1 sky130_fd_sc_hd__diode_2
XFILLER_27_337 vccd1 vssd1 vccd1 vssd1 sky130_ef_sc_hd__decap_12
X_3078_ _3065_/X _3067_/Y _3104_/B _3077_/X vssd1 vssd1 vccd1 vccd1 _3078_/X sky130_fd_sc_hd__o211a_1
XANTENNA_fanout440_A input2/X vssd1 vssd1 vccd1 vccd1 sky130_fd_sc_hd__diode_2
XFILLER_42_329 vssd1 vssd1 vccd1 vccd1 sky130_fd_sc_hd__fill_2
XANTENNA_fanout326_X _4005_/D vssd1 vssd1 vccd1 vccd1 sky130_fd_sc_hd__diode_2
XANTENNA__4188__A1 _4320_/A vssd1 vssd1 vccd1 vccd1 sky130_fd_sc_hd__diode_2
XFILLER_6_208 vssd1 vssd1 vccd1 vccd1 sky130_fd_sc_hd__fill_2
XANTENNA__3935__A1 _3971_/A1 vssd1 vssd1 vccd1 vccd1 sky130_fd_sc_hd__diode_2
XFILLER_6_219 vssd1 vssd1 vccd1 vccd1 sky130_fd_sc_hd__decap_3
XFILLER_40_57 vssd1 vssd1 vccd1 vccd1 sky130_fd_sc_hd__fill_1
XFILLER_40_79 vssd1 vssd1 vccd1 vccd1 sky130_fd_sc_hd__decap_4
XFILLER_77_215 vssd1 vssd1 vccd1 vccd1 sky130_fd_sc_hd__fill_2
XTAP_TAPCELL_ROW_5_230 vssd1 vccd1 sky130_fd_sc_hd__tapvpwrvgnd_1
XFILLER_1_18 vccd1 vssd1 vccd1 vssd1 sky130_ef_sc_hd__decap_12
XFILLER_58_451 vssd1 vssd1 vccd1 vccd1 sky130_fd_sc_hd__decap_6
XTAP_TAPCELL_ROW_48_619 vssd1 vccd1 sky130_fd_sc_hd__tapvpwrvgnd_1
XFILLER_85_281 vssd1 vssd1 vccd1 vccd1 sky130_fd_sc_hd__decap_4
XANTENNA__4392__S _4408_/S vssd1 vssd1 vccd1 vccd1 sky130_fd_sc_hd__diode_2
XFILLER_81_20 vccd1 vssd1 vccd1 vssd1 sky130_ef_sc_hd__decap_12
XFILLER_26_392 vccd1 vssd1 vccd1 vssd1 sky130_ef_sc_hd__decap_12
XTAP_TAPCELL_ROW_56_696 vssd1 vccd1 sky130_fd_sc_hd__tapvpwrvgnd_1
XANTENNA__2206__A _4468_/Q vssd1 vssd1 vccd1 vccd1 sky130_fd_sc_hd__diode_2
XFILLER_14_91 vssd1 vssd1 vccd1 vccd1 sky130_fd_sc_hd__decap_8
XTAP_TAPCELL_ROW_11_287 vssd1 vccd1 sky130_fd_sc_hd__tapvpwrvgnd_1
XFILLER_53_7 vssd1 vssd1 vccd1 vccd1 sky130_fd_sc_hd__fill_1
X_2380_ hold11/X _2379_/X _2382_/S vssd1 vssd1 vccd1 vccd1 _4485_/D sky130_fd_sc_hd__mux2_1
X_4050_ _4049_/Y _4048_/X _4047_/X _4704_/Q _4058_/B2 vssd1 vssd1 vccd1 vccd1 _4704_/D
+ sky130_fd_sc_hd__o32a_1
XFILLER_49_451 vssd1 vssd1 vccd1 vccd1 sky130_fd_sc_hd__decap_4
Xinput6 s_axis_tdata[12] vssd1 vssd1 vccd1 vccd1 input6/X sky130_fd_sc_hd__clkbuf_1
X_3001_ _3001_/A _3001_/B vssd1 vssd1 vccd1 vccd1 _3001_/X sky130_fd_sc_hd__or2_1
XFILLER_64_421 vssd1 vssd1 vccd1 vccd1 sky130_fd_sc_hd__decap_4
XFILLER_24_307 vssd1 vssd1 vccd1 vccd1 sky130_fd_sc_hd__fill_1
XFILLER_36_145 vssd1 vssd1 vccd1 vccd1 sky130_fd_sc_hd__fill_1
XFILLER_17_381 vssd1 vssd1 vccd1 vccd1 sky130_fd_sc_hd__decap_4
X_3903_ _3979_/A2 _2338_/B _3902_/Y vssd1 vssd1 vccd1 vccd1 _4659_/D sky130_fd_sc_hd__a21oi_1
X_3834_ hold199/X _3848_/A2 _3833_/Y vssd1 vssd1 vccd1 vccd1 _4635_/D sky130_fd_sc_hd__a21o_1
XANTENNA__3917__A1 _4377_/C1 vssd1 vssd1 vccd1 vccd1 sky130_fd_sc_hd__diode_2
X_3765_ _4535_/Q _4644_/Q vssd1 vssd1 vccd1 vccd1 _3767_/C sky130_fd_sc_hd__nand2b_1
XANTENNA__4739__RESET_B fanout382/X vssd1 vssd1 vccd1 vccd1 sky130_fd_sc_hd__diode_2
X_2716_ _2716_/A _2716_/B _2716_/C _2716_/D vssd1 vssd1 vccd1 vccd1 _2717_/C sky130_fd_sc_hd__nand4_1
X_3696_ _3741_/S _3696_/B vssd1 vssd1 vccd1 vccd1 _3696_/Y sky130_fd_sc_hd__nor2_1
XANTENNA_fanout119_A _2930_/A2 vssd1 vssd1 vccd1 vccd1 sky130_fd_sc_hd__diode_2
X_2647_ _2648_/B _2648_/C _2648_/A vssd1 vssd1 vccd1 vccd1 _2649_/A sky130_fd_sc_hd__a21o_1
X_2578_ _2578_/A _4663_/Q _2617_/D vssd1 vssd1 vccd1 vccd1 _2580_/A sky130_fd_sc_hd__and3_1
X_4317_ _4316_/A _4344_/B _4334_/A2 vssd1 vssd1 vccd1 vccd1 _4317_/Y sky130_fd_sc_hd__o21ai_1
XFILLER_59_237 vssd1 vssd1 vccd1 vccd1 sky130_fd_sc_hd__decap_4
X_4248_ _4754_/Q _4295_/B1 _4245_/X _4247_/X vssd1 vssd1 vccd1 vccd1 _4754_/D sky130_fd_sc_hd__o22a_1
XTAP_TAPCELL_ROW_2_211 vssd1 vccd1 sky130_fd_sc_hd__tapvpwrvgnd_1
X_4179_ _4178_/D _4179_/B _4179_/C vssd1 vssd1 vccd1 vccd1 _4179_/X sky130_fd_sc_hd__and3b_1
XFILLER_67_281 vssd1 vssd1 vccd1 vccd1 sky130_fd_sc_hd__decap_8
XFILLER_55_432 vssd1 vssd1 vccd1 vccd1 sky130_fd_sc_hd__decap_4
XFILLER_70_402 vssd1 vssd1 vccd1 vccd1 sky130_fd_sc_hd__decap_8
XFILLER_27_167 vssd1 vssd1 vccd1 vccd1 sky130_fd_sc_hd__fill_1
XTAP_TAPCELL_ROW_81_920 vssd1 vccd1 sky130_fd_sc_hd__tapvpwrvgnd_1
XFILLER_42_148 vccd1 vssd1 vccd1 vssd1 sky130_ef_sc_hd__decap_12
XTAP_TAPCELL_ROW_53_666 vssd1 vccd1 sky130_fd_sc_hd__tapvpwrvgnd_1
XFILLER_23_373 vssd1 vssd1 vccd1 vccd1 sky130_fd_sc_hd__decap_6
XPHY_EDGE_ROW_14_Right_14 vssd1 vssd1 vccd1 vccd1 sky130_fd_sc_hd__decap_3
XANTENNA__3908__A1 _3946_/A2 vssd1 vssd1 vccd1 vccd1 sky130_fd_sc_hd__diode_2
XANTENNA__4333__A1 _4332_/A vssd1 vssd1 vccd1 vccd1 sky130_fd_sc_hd__diode_2
XANTENNA_fanout91_X _4397_/S vssd1 vssd1 vccd1 vccd1 sky130_fd_sc_hd__diode_2
XFILLER_2_233 vssd1 vssd1 vccd1 vccd1 sky130_fd_sc_hd__fill_1
XANTENNA__2344__B1 _4468_/Q vssd1 vssd1 vccd1 vccd1 sky130_fd_sc_hd__diode_2
XANTENNA__4387__S _4408_/S vssd1 vssd1 vccd1 vccd1 sky130_fd_sc_hd__diode_2
XPHY_EDGE_ROW_23_Right_23 vssd1 vssd1 vccd1 vccd1 sky130_fd_sc_hd__decap_3
XFILLER_76_97 vssd1 vssd1 vccd1 vccd1 sky130_fd_sc_hd__decap_8
XTAP_TAPCELL_ROW_16_335 vssd1 vccd1 sky130_fd_sc_hd__tapvpwrvgnd_1
XPHY_EDGE_ROW_32_Right_32 vssd1 vssd1 vccd1 vccd1 sky130_fd_sc_hd__decap_3
XFILLER_14_362 vssd1 vssd1 vccd1 vccd1 sky130_fd_sc_hd__fill_2
X_3550_ _4583_/Q _3603_/S _3549_/X vssd1 vssd1 vccd1 vccd1 _4583_/D sky130_fd_sc_hd__a21o_1
X_2501_ _2501_/A _2501_/B vssd1 vssd1 vccd1 vccd1 _2502_/B sky130_fd_sc_hd__xnor2_1
X_3481_ _3481_/A _3481_/B vssd1 vssd1 vccd1 vccd1 _3481_/Y sky130_fd_sc_hd__nand2_1
X_2432_ _4671_/Q _4452_/Q vssd1 vssd1 vccd1 vccd1 _2434_/A sky130_fd_sc_hd__and2_1
XPHY_EDGE_ROW_41_Right_41 vssd1 vssd1 vccd1 vccd1 sky130_fd_sc_hd__decap_3
XFILLER_44_3 vssd1 vssd1 vccd1 vccd1 sky130_fd_sc_hd__fill_1
XANTENNA__4297__S _4368_/A vssd1 vssd1 vccd1 vccd1 sky130_fd_sc_hd__diode_2
X_2363_ _4549_/Q hold31/A _2365_/S vssd1 vssd1 vccd1 vccd1 _2363_/X sky130_fd_sc_hd__mux2_1
X_4102_ _4101_/Y _4100_/X _4099_/X hold104/X _4225_/B2 vssd1 vssd1 vccd1 vccd1 _4717_/D
+ sky130_fd_sc_hd__o32a_1
X_2294_ _3875_/A0 _2310_/A1 _4332_/A vssd1 vssd1 vccd1 vccd1 _2294_/X sky130_fd_sc_hd__mux2_1
X_4033_ _4104_/C _4037_/B _4033_/C _4033_/D vssd1 vssd1 vccd1 vccd1 _4033_/X sky130_fd_sc_hd__and4b_1
XFILLER_2_83 vssd1 vssd1 vccd1 vccd1 sky130_fd_sc_hd__fill_1
XANTENNA__4029__C _4033_/C vssd1 vssd1 vccd1 vccd1 sky130_fd_sc_hd__diode_2
XFILLER_49_281 vccd1 vssd1 vccd1 vssd1 sky130_ef_sc_hd__decap_12
XFILLER_37_465 vssd1 vssd1 vccd1 vccd1 sky130_fd_sc_hd__fill_1
XFILLER_52_402 vssd1 vssd1 vccd1 vccd1 sky130_fd_sc_hd__decap_4
XPHY_EDGE_ROW_50_Right_50 vssd1 vssd1 vccd1 vccd1 sky130_fd_sc_hd__decap_3
XFILLER_52_413 vssd1 vssd1 vccd1 vccd1 sky130_fd_sc_hd__decap_4
XANTENNA_fanout236_A _2250_/S vssd1 vssd1 vccd1 vccd1 sky130_fd_sc_hd__diode_2
XTAP_TAPCELL_ROW_50_636 vssd1 vccd1 sky130_fd_sc_hd__tapvpwrvgnd_1
X_4797_ _4815_/CLK _4797_/D fanout394/X vssd1 vssd1 vccd1 vccd1 _4797_/Q sky130_fd_sc_hd__dfrtp_2
XFILLER_20_365 vccd1 vssd1 vccd1 vssd1 sky130_ef_sc_hd__decap_12
X_3817_ _2585_/Y _2593_/X _2594_/Y vssd1 vssd1 vccd1 vccd1 _3817_/Y sky130_fd_sc_hd__a21oi_1
XANTENNA_fanout403_A fanout404/X vssd1 vssd1 vccd1 vccd1 sky130_fd_sc_hd__diode_2
X_3748_ _3748_/A _3748_/B vssd1 vssd1 vccd1 vccd1 _3748_/Y sky130_fd_sc_hd__nand2_1
XANTENNA__2280__S _3928_/S vssd1 vssd1 vccd1 vccd1 sky130_fd_sc_hd__diode_2
XFILLER_21_37 vssd1 vssd1 vccd1 vccd1 sky130_fd_sc_hd__fill_1
XANTENNA__3366__A2 _3423_/A1 vssd1 vssd1 vccd1 vccd1 sky130_fd_sc_hd__diode_2
X_3679_ _3685_/A _3679_/B vssd1 vssd1 vccd1 vccd1 _3679_/X sky130_fd_sc_hd__xor2_1
XANTENNA__4211__D _4239_/D vssd1 vssd1 vccd1 vccd1 sky130_fd_sc_hd__diode_2
XFILLER_87_321 vccd1 vssd1 vccd1 vssd1 sky130_ef_sc_hd__decap_12
XANTENNA__4000__S _4005_/D vssd1 vssd1 vccd1 vccd1 sky130_fd_sc_hd__diode_2
XFILLER_87_365 vccd1 vssd1 vccd1 vssd1 sky130_ef_sc_hd__decap_12
XTAP_TAPCELL_ROW_58_714 vssd1 vccd1 sky130_fd_sc_hd__tapvpwrvgnd_1
XTAP_TAPCELL_ROW_66_780 vssd1 vccd1 sky130_fd_sc_hd__tapvpwrvgnd_1
XFILLER_28_487 vssd1 vssd1 vccd1 vccd1 sky130_fd_sc_hd__fill_1
XFILLER_43_424 vssd1 vssd1 vccd1 vccd1 sky130_fd_sc_hd__decap_4
XFILLER_70_287 vssd1 vssd1 vccd1 vccd1 sky130_fd_sc_hd__decap_6
XFILLER_70_265 vssd1 vssd1 vccd1 vccd1 sky130_fd_sc_hd__decap_6
XTAP_TAPCELL_ROW_13_305 vssd1 vccd1 sky130_fd_sc_hd__tapvpwrvgnd_1
Xclkbuf_leaf_50_clk clkload0/A vssd1 vssd1 vccd1 vccd1 _4808_/CLK sky130_fd_sc_hd__clkbuf_8
XANTENNA__3357__A2 _3425_/A2 vssd1 vssd1 vccd1 vccd1 sky130_fd_sc_hd__diode_2
XFILLER_7_39 vccd1 vssd1 vccd1 vssd1 sky130_ef_sc_hd__decap_12
XTAP_TAPCELL_ROW_21_382 vssd1 vccd1 sky130_fd_sc_hd__tapvpwrvgnd_1
XFILLER_87_41 vccd1 vssd1 vccd1 vssd1 sky130_ef_sc_hd__decap_12
XFILLER_78_365 vssd1 vssd1 vccd1 vccd1 sky130_fd_sc_hd__decap_8
XFILLER_19_421 vssd1 vssd1 vccd1 vccd1 sky130_fd_sc_hd__decap_8
XFILLER_19_465 vssd1 vssd1 vccd1 vccd1 sky130_fd_sc_hd__fill_1
XANTENNA__2365__S _2365_/S vssd1 vssd1 vccd1 vccd1 sky130_fd_sc_hd__diode_2
X_2981_ _3033_/A _2949_/B _2978_/A _2952_/B _2978_/B vssd1 vssd1 vccd1 vccd1 _2981_/Y
+ sky130_fd_sc_hd__a2111oi_2
XFILLER_61_254 vssd1 vssd1 vccd1 vccd1 sky130_fd_sc_hd__fill_1
Xclkbuf_leaf_41_clk clkload2/A vssd1 vssd1 vccd1 vccd1 _4669_/CLK sky130_fd_sc_hd__clkbuf_8
X_4720_ clkload3/A _4720_/D fanout376/X vssd1 vssd1 vccd1 vccd1 _4720_/Q sky130_fd_sc_hd__dfrtp_1
X_4651_ _4687_/CLK _4651_/D fanout406/X vssd1 vssd1 vccd1 vccd1 _4651_/Q sky130_fd_sc_hd__dfrtp_1
Xinput20 s_axis_tdata[25] vssd1 vssd1 vccd1 vccd1 input20/X sky130_fd_sc_hd__clkbuf_1
XANTENNA__3348__A2 _3425_/A2 vssd1 vssd1 vccd1 vccd1 sky130_fd_sc_hd__diode_2
Xinput31 s_axis_tdata[6] vssd1 vssd1 vccd1 vccd1 input31/X sky130_fd_sc_hd__clkbuf_1
X_3602_ _3602_/A _3602_/B vssd1 vssd1 vccd1 vccd1 _3602_/Y sky130_fd_sc_hd__xnor2_1
X_4582_ _4587_/CLK _4582_/D fanout408/X vssd1 vssd1 vccd1 vccd1 _4582_/Q sky130_fd_sc_hd__dfrtp_2
X_3533_ _3536_/A2 _3531_/Y _3532_/X _3536_/B1 vssd1 vssd1 vccd1 vccd1 _3533_/X sky130_fd_sc_hd__a31o_1
X_3464_ _3302_/A _3302_/B _3463_/B vssd1 vssd1 vccd1 vccd1 _3464_/X sky130_fd_sc_hd__a21o_1
X_2415_ _4575_/Q hold65/A _2421_/S vssd1 vssd1 vccd1 vccd1 _2415_/X sky130_fd_sc_hd__mux2_1
X_3395_ _4593_/Q _3424_/A2 _3395_/B1 _3925_/S vssd1 vssd1 vccd1 vccd1 _3395_/X sky130_fd_sc_hd__o211a_1
XFILLER_69_376 vssd1 vssd1 vccd1 vccd1 sky130_fd_sc_hd__fill_1
X_2346_ _4539_/Q _3158_/B _2230_/X _3158_/A vssd1 vssd1 vccd1 vccd1 _2346_/X sky130_fd_sc_hd__a2bb2o_1
X_2277_ _4001_/C _2295_/B _2340_/B vssd1 vssd1 vccd1 vccd1 _2277_/Y sky130_fd_sc_hd__nor3_1
X_4016_ _4036_/A0 _4036_/A1 _4021_/D vssd1 vssd1 vccd1 vccd1 _4016_/X sky130_fd_sc_hd__mux2_1
XANTENNA_fanout353_A _4377_/B1 vssd1 vssd1 vccd1 vccd1 sky130_fd_sc_hd__diode_2
XANTENNA_fanout239_X _2270_/S vssd1 vssd1 vccd1 vccd1 sky130_fd_sc_hd__diode_2
Xclkbuf_leaf_32_clk clkbuf_2_3__f_clk/X vssd1 vssd1 vccd1 vccd1 _4635_/CLK sky130_fd_sc_hd__clkbuf_8
XFILLER_32_14 vssd1 vssd1 vccd1 vccd1 sky130_fd_sc_hd__fill_1
XFILLER_0_501 vssd1 vssd1 vccd1 vccd1 sky130_fd_sc_hd__decap_3
XANTENNA__4148__A_N _4239_/D vssd1 vssd1 vccd1 vccd1 sky130_fd_sc_hd__diode_2
XFILLER_57_22 vssd1 vssd1 vccd1 vccd1 sky130_fd_sc_hd__fill_1
XFILLER_75_335 vssd1 vssd1 vccd1 vccd1 sky130_fd_sc_hd__fill_1
XFILLER_43_210 vssd1 vssd1 vccd1 vccd1 sky130_fd_sc_hd__decap_8
Xclkbuf_leaf_23_clk clkbuf_2_3__f_clk/X vssd1 vssd1 vccd1 vccd1 _4612_/CLK sky130_fd_sc_hd__clkbuf_8
XFILLER_31_449 vccd1 vssd1 vccd1 vssd1 sky130_ef_sc_hd__decap_12
XFILLER_11_184 vssd1 vssd1 vccd1 vccd1 sky130_fd_sc_hd__fill_2
XANTENNA__3750__A2 _3735_/S vssd1 vssd1 vccd1 vccd1 sky130_fd_sc_hd__diode_2
XTAP_TAPCELL_ROW_69_809 vssd1 vccd1 sky130_fd_sc_hd__tapvpwrvgnd_1
XANTENNA__3502__A2 _3522_/A2 vssd1 vssd1 vccd1 vccd1 sky130_fd_sc_hd__diode_2
X_3180_ _4567_/Q _4608_/Q vssd1 vssd1 vccd1 vccd1 _3475_/B sky130_fd_sc_hd__nor2_1
XFILLER_39_505 vssd1 vssd1 vccd1 vccd1 sky130_fd_sc_hd__fill_1
XTAP_TAPCELL_ROW_77_886 vssd1 vccd1 sky130_fd_sc_hd__tapvpwrvgnd_1
XFILLER_81_349 vccd1 vssd1 vccd1 vssd1 sky130_ef_sc_hd__decap_12
X_2964_ _2964_/A _2964_/B _2964_/C vssd1 vssd1 vccd1 vccd1 _2967_/C sky130_fd_sc_hd__or3_1
XTAP_TAPCELL_ROW_60_731 vssd1 vccd1 sky130_fd_sc_hd__tapvpwrvgnd_1
Xclkbuf_leaf_14_clk clkload1/A vssd1 vssd1 vccd1 vccd1 _4817_/CLK sky130_fd_sc_hd__clkbuf_8
X_4703_ clkload4/A _4703_/D fanout377/X vssd1 vssd1 vccd1 vccd1 _4703_/Q sky130_fd_sc_hd__dfrtp_1
XTAP_TAPCELL_ROW_32_477 vssd1 vccd1 sky130_fd_sc_hd__tapvpwrvgnd_1
X_2895_ _2896_/A _2895_/B _2895_/C vssd1 vssd1 vccd1 vccd1 _2895_/X sky130_fd_sc_hd__or3_1
X_4634_ _4635_/CLK _4634_/D fanout425/X vssd1 vssd1 vccd1 vccd1 _4634_/Q sky130_fd_sc_hd__dfrtp_1
X_4565_ _4605_/CLK _4565_/D fanout426/X vssd1 vssd1 vccd1 vccd1 _4565_/Q sky130_fd_sc_hd__dfrtp_2
X_3516_ _3516_/A _3516_/B vssd1 vssd1 vccd1 vccd1 _3516_/X sky130_fd_sc_hd__xor2_1
XANTENNA_fanout101_A _3542_/X vssd1 vssd1 vccd1 vccd1 sky130_fd_sc_hd__diode_2
X_4496_ _4579_/CLK _4496_/D fanout437/X vssd1 vssd1 vccd1 vccd1 hold18/A sky130_fd_sc_hd__dfrtp_1
XPHY_EDGE_ROW_4_Right_4 vssd1 vssd1 vccd1 vccd1 sky130_fd_sc_hd__decap_3
X_3447_ _3447_/A _3447_/B vssd1 vssd1 vccd1 vccd1 _3447_/X sky130_fd_sc_hd__xor2_1
XANTENNA_clkbuf_leaf_15_clk_A clkload1/A vssd1 vssd1 vccd1 vccd1 sky130_fd_sc_hd__diode_2
X_3378_ _4590_/Q _3384_/A2 _3395_/B1 _3561_/C vssd1 vssd1 vccd1 vccd1 _3378_/X sky130_fd_sc_hd__o211a_1
X_2329_ _2328_/Y _2327_/X _2326_/X hold138/X _4015_/B2 vssd1 vssd1 vccd1 vccd1 _4464_/D
+ sky130_fd_sc_hd__o32a_1
XFILLER_27_69 vssd1 vssd1 vccd1 vccd1 sky130_fd_sc_hd__decap_4
XANTENNA_fanout356_X _3613_/B vssd1 vssd1 vccd1 vccd1 sky130_fd_sc_hd__diode_2
XANTENNA__4206__A0 _4214_/A0 vssd1 vssd1 vccd1 vccd1 sky130_fd_sc_hd__diode_2
XTAP_TAPCELL_ROW_23_400 vssd1 vccd1 sky130_fd_sc_hd__tapvpwrvgnd_1
XFILLER_21_471 vssd1 vssd1 vccd1 vccd1 sky130_fd_sc_hd__fill_1
XANTENNA_input31_A s_axis_tdata[6] vssd1 vssd1 vccd1 vccd1 sky130_fd_sc_hd__diode_2
XANTENNA__4395__S _4397_/S vssd1 vssd1 vccd1 vccd1 sky130_fd_sc_hd__diode_2
XFILLER_84_53 vccd1 vssd1 vccd1 vssd1 sky130_ef_sc_hd__decap_12
XTAP_TAPCELL_ROW_74_856 vssd1 vccd1 sky130_fd_sc_hd__tapvpwrvgnd_1
XFILLER_71_393 vssd1 vssd1 vccd1 vccd1 sky130_fd_sc_hd__decap_3
XFILLER_71_371 vccd1 vssd1 vccd1 vssd1 sky130_ef_sc_hd__decap_12
XFILLER_16_287 vssd1 vssd1 vccd1 vccd1 sky130_fd_sc_hd__fill_1
XFILLER_31_246 vssd1 vssd1 vccd1 vccd1 sky130_fd_sc_hd__decap_3
X_2680_ _4664_/Q _4755_/Q _2679_/A vssd1 vssd1 vccd1 vccd1 _2682_/C sky130_fd_sc_hd__a21o_1
X_4350_ _4349_/Y _4348_/X _4347_/X _4780_/Q _4358_/A2 vssd1 vssd1 vccd1 vccd1 _4780_/D
+ sky130_fd_sc_hd__o32a_1
X_3301_ _3301_/A _3463_/B _3301_/C _3301_/D vssd1 vssd1 vccd1 vccd1 _3301_/X sky130_fd_sc_hd__or4_1
X_4281_ _4281_/A0 _4281_/A1 _4352_/A vssd1 vssd1 vccd1 vccd1 _4281_/X sky130_fd_sc_hd__mux2_1
XFILLER_86_408 vccd1 vssd1 vccd1 vssd1 sky130_ef_sc_hd__decap_12
X_3232_ _4554_/Q _4595_/Q vssd1 vssd1 vccd1 vccd1 _3406_/A sky130_fd_sc_hd__and2_1
Xclkbuf_leaf_3_clk clkload0/A vssd1 vssd1 vccd1 vccd1 clkload6/A sky130_fd_sc_hd__clkbuf_8
X_3163_ _4571_/Q _4612_/Q vssd1 vssd1 vccd1 vccd1 _3166_/A sky130_fd_sc_hd__nand2_1
XFILLER_66_121 vssd1 vssd1 vccd1 vccd1 sky130_fd_sc_hd__decap_6
XANTENNA_clkbuf_2_2__f_clk_X clkload2/A vssd1 vssd1 vccd1 vccd1 sky130_fd_sc_hd__diode_2
XFILLER_81_113 vssd1 vssd1 vccd1 vccd1 sky130_fd_sc_hd__fill_2
X_3094_ _3094_/A vssd1 vssd1 vccd1 vccd1 _3094_/Y sky130_fd_sc_hd__inv_2
XFILLER_54_327 vccd1 vssd1 vccd1 vssd1 sky130_ef_sc_hd__decap_12
XTAP_TAPCELL_ROW_37_525 vssd1 vccd1 sky130_fd_sc_hd__tapvpwrvgnd_1
XANTENNA__4037__C _4037_/C vssd1 vssd1 vccd1 vccd1 sky130_fd_sc_hd__diode_2
X_3996_ _4020_/A0 _4020_/A1 _4063_/S vssd1 vssd1 vccd1 vccd1 _3996_/X sky130_fd_sc_hd__mux2_1
XFILLER_22_257 vssd1 vssd1 vccd1 vccd1 sky130_fd_sc_hd__fill_1
XTAP_TAPCELL_ROW_45_591 vssd1 vccd1 sky130_fd_sc_hd__tapvpwrvgnd_1
X_2947_ _2911_/B _2911_/A _2909_/Y vssd1 vssd1 vccd1 vccd1 _2947_/X sky130_fd_sc_hd__o21a_1
XANTENNA_fanout316_A _3950_/A2 vssd1 vssd1 vccd1 vccd1 sky130_fd_sc_hd__diode_2
X_4617_ _4669_/CLK _4617_/D fanout406/X vssd1 vssd1 vccd1 vccd1 _4617_/Q sky130_fd_sc_hd__dfrtp_1
X_2878_ _4747_/Q _4717_/Q vssd1 vssd1 vccd1 vccd1 _2880_/C sky130_fd_sc_hd__and2_1
X_4548_ _4553_/CLK _4548_/D fanout419/X vssd1 vssd1 vccd1 vccd1 hold87/A sky130_fd_sc_hd__dfrtp_1
X_4479_ _4820_/CLK _4479_/D fanout420/X vssd1 vssd1 vccd1 vccd1 hold82/A sky130_fd_sc_hd__dfrtp_1
XPHY_EDGE_ROW_79_Right_79 vssd1 vssd1 vccd1 vccd1 sky130_fd_sc_hd__decap_3
XFILLER_72_179 vssd1 vssd1 vccd1 vccd1 sky130_fd_sc_hd__decap_8
XTAP_TAPCELL_ROW_71_826 vssd1 vccd1 sky130_fd_sc_hd__tapvpwrvgnd_1
XTAP_TAPCELL_ROW_0_183 vssd1 vccd1 sky130_fd_sc_hd__tapvpwrvgnd_1
XFILLER_13_279 vssd1 vssd1 vccd1 vccd1 sky130_fd_sc_hd__fill_1
XFILLER_70_55 vccd1 vssd1 vccd1 vssd1 sky130_ef_sc_hd__decap_12
XTAP_TAPCELL_ROW_79_904 vssd1 vccd1 sky130_fd_sc_hd__tapvpwrvgnd_1
XTAP_TAPCELL_ROW_8_261 vssd1 vccd1 sky130_fd_sc_hd__tapvpwrvgnd_1
XFILLER_48_110 vssd1 vssd1 vccd1 vccd1 sky130_fd_sc_hd__fill_1
XTAP_TAPCELL_ROW_87_981 vssd1 vccd1 sky130_fd_sc_hd__tapvpwrvgnd_1
XTAP_TAPCELL_ROW_87_970 vssd1 vccd1 sky130_fd_sc_hd__tapvpwrvgnd_1
XFILLER_63_146 vssd1 vssd1 vccd1 vccd1 sky130_fd_sc_hd__fill_1
XFILLER_51_319 vssd1 vssd1 vccd1 vccd1 sky130_fd_sc_hd__fill_1
XFILLER_44_393 vccd1 vssd1 vccd1 vssd1 sky130_ef_sc_hd__decap_12
X_3850_ _4643_/Q _3869_/S _3094_/A _3849_/Y vssd1 vssd1 vccd1 vccd1 _4643_/D sky130_fd_sc_hd__a22o_1
X_3781_ _4536_/Q _4645_/Q _3776_/X _3768_/Y _3780_/A vssd1 vssd1 vccd1 vccd1 _3781_/Y
+ sky130_fd_sc_hd__o221ai_4
X_2801_ _2869_/B _4700_/Q vssd1 vssd1 vccd1 vccd1 _2801_/Y sky130_fd_sc_hd__nor2_1
XFILLER_12_290 vssd1 vssd1 vccd1 vccd1 sky130_fd_sc_hd__decap_6
X_2732_ _2770_/A _4698_/Q _4466_/Q vssd1 vssd1 vccd1 vccd1 _2785_/C sky130_fd_sc_hd__o21ai_1
XFILLER_8_272 vccd1 vssd1 vccd1 vssd1 sky130_ef_sc_hd__decap_12
X_2663_ _4696_/Q _4683_/Q vssd1 vssd1 vccd1 vccd1 _2716_/C sky130_fd_sc_hd__nand2_1
X_4402_ _4116_/D input18/X _4402_/S vssd1 vssd1 vccd1 vccd1 _4811_/D sky130_fd_sc_hd__mux2_1
X_2594_ _2585_/Y _2593_/X _3870_/B1 vssd1 vssd1 vccd1 vccd1 _2594_/Y sky130_fd_sc_hd__o21ai_1
XANTENNA__4320__C _4328_/C vssd1 vssd1 vccd1 vccd1 sky130_fd_sc_hd__diode_2
X_4333_ _4332_/A _4328_/C _4328_/B _4376_/A2 _4332_/Y vssd1 vssd1 vccd1 vccd1 _4333_/X
+ sky130_fd_sc_hd__a311o_1
Xfanout229 _3907_/X vssd1 vssd1 vccd1 vccd1 _4081_/A2 sky130_fd_sc_hd__buf_2
Xfanout207 _2277_/Y vssd1 vssd1 vccd1 vccd1 _2341_/A1 sky130_fd_sc_hd__clkbuf_2
X_4264_ _4263_/Y _4262_/X _4261_/X _4758_/Q _4264_/B2 vssd1 vssd1 vccd1 vccd1 _4758_/D
+ sky130_fd_sc_hd__o32a_1
Xfanout218 _4377_/C1 vssd1 vssd1 vccd1 vccd1 _3543_/A sky130_fd_sc_hd__clkbuf_2
X_3215_ _4564_/Q _4605_/Q _4604_/Q vssd1 vssd1 vccd1 vccd1 _3215_/X sky130_fd_sc_hd__o21a_1
XFILLER_86_249 vssd1 vssd1 vccd1 vccd1 sky130_fd_sc_hd__decap_3
XANTENNA__4121__A2 _4173_/A2 vssd1 vssd1 vccd1 vccd1 sky130_fd_sc_hd__diode_2
XFILLER_39_121 vssd1 vssd1 vccd1 vccd1 sky130_fd_sc_hd__decap_6
XFILLER_39_132 vssd1 vssd1 vccd1 vccd1 sky130_fd_sc_hd__decap_8
X_4195_ _4258_/C _4211_/B _4323_/S _4199_/D vssd1 vssd1 vccd1 vccd1 _4195_/X sky130_fd_sc_hd__and4b_1
X_3146_ _3147_/A _3147_/B vssd1 vssd1 vccd1 vccd1 _3146_/X sky130_fd_sc_hd__and2b_1
X_3077_ _3862_/C _3862_/D _3104_/A _3076_/D vssd1 vssd1 vccd1 vccd1 _3077_/X sky130_fd_sc_hd__a22o_1
XFILLER_27_349 vccd1 vssd1 vccd1 vssd1 sky130_ef_sc_hd__decap_12
XFILLER_82_477 vccd1 vssd1 vccd1 vssd1 sky130_ef_sc_hd__decap_12
XFILLER_42_319 vssd1 vssd1 vccd1 vccd1 sky130_fd_sc_hd__fill_2
XANTENNA__4188__A2 _4212_/A2 vssd1 vssd1 vccd1 vccd1 sky130_fd_sc_hd__diode_2
X_3979_ _4686_/Q _3979_/A2 _3976_/X _3978_/X vssd1 vssd1 vccd1 vccd1 _4686_/D sky130_fd_sc_hd__o22a_1
XANTENNA_fanout319_X _3950_/A2 vssd1 vssd1 vccd1 vccd1 sky130_fd_sc_hd__diode_2
XFILLER_6_6 vssd1 vssd1 vccd1 vccd1 sky130_fd_sc_hd__fill_1
XANTENNA_fanout81_A _3460_/A1 vssd1 vssd1 vccd1 vccd1 sky130_fd_sc_hd__diode_2
XTAP_TAPCELL_ROW_5_231 vssd1 vccd1 sky130_fd_sc_hd__tapvpwrvgnd_1
XFILLER_73_400 vssd1 vssd1 vccd1 vccd1 sky130_fd_sc_hd__fill_2
XFILLER_18_305 vssd1 vssd1 vccd1 vccd1 sky130_fd_sc_hd__decap_3
XFILLER_65_55 vssd1 vssd1 vccd1 vccd1 sky130_fd_sc_hd__fill_1
XFILLER_45_113 vccd1 vssd1 vccd1 vssd1 sky130_ef_sc_hd__decap_12
XFILLER_73_477 vssd1 vssd1 vccd1 vccd1 sky130_fd_sc_hd__decap_3
XTAP_TAPCELL_ROW_56_697 vssd1 vccd1 sky130_fd_sc_hd__tapvpwrvgnd_1
XFILLER_81_32 vssd1 vssd1 vccd1 vccd1 sky130_fd_sc_hd__fill_1
XFILLER_41_352 vssd1 vssd1 vccd1 vccd1 sky130_fd_sc_hd__fill_1
XFILLER_41_374 vssd1 vssd1 vccd1 vccd1 sky130_fd_sc_hd__decap_8
XFILLER_14_81 vssd1 vssd1 vccd1 vccd1 sky130_fd_sc_hd__decap_3
XANTENNA__4124__D _4324_/A vssd1 vssd1 vccd1 vccd1 sky130_fd_sc_hd__diode_2
XTAP_TAPCELL_ROW_11_288 vssd1 vccd1 sky130_fd_sc_hd__tapvpwrvgnd_1
XFILLER_68_227 vssd1 vssd1 vccd1 vccd1 sky130_fd_sc_hd__fill_1
XFILLER_1_481 vccd1 vssd1 vccd1 vssd1 sky130_ef_sc_hd__decap_12
Xinput7 s_axis_tdata[13] vssd1 vssd1 vccd1 vccd1 input7/X sky130_fd_sc_hd__clkbuf_1
X_3000_ _3000_/A _3000_/B _3000_/C vssd1 vssd1 vccd1 vccd1 _3001_/B sky130_fd_sc_hd__and3_1
X_3902_ _3943_/A2 _3946_/A1 hold139/X vssd1 vssd1 vccd1 vccd1 _3902_/Y sky130_fd_sc_hd__a21oi_1
X_3833_ _2851_/Y _2864_/X _2865_/Y vssd1 vssd1 vccd1 vccd1 _3833_/Y sky130_fd_sc_hd__a21oi_1
X_3764_ _3764_/A vssd1 vssd1 vccd1 vccd1 _3767_/B sky130_fd_sc_hd__inv_2
XANTENNA__3917__A2 _4377_/B1 vssd1 vssd1 vccd1 vccd1 sky130_fd_sc_hd__diode_2
X_2715_ _2716_/A _2716_/B _2716_/C _2716_/D vssd1 vssd1 vccd1 vccd1 _2717_/B sky130_fd_sc_hd__a22o_1
X_3695_ _3727_/A _3727_/B _3660_/Y _3689_/A _3725_/A vssd1 vssd1 vccd1 vccd1 _3696_/B
+ sky130_fd_sc_hd__o311a_1
X_2646_ _2646_/A _2646_/B vssd1 vssd1 vccd1 vccd1 _2648_/C sky130_fd_sc_hd__nand2_1
XANTENNA__4342__A2 _2273_/X vssd1 vssd1 vccd1 vccd1 sky130_fd_sc_hd__diode_2
XFILLER_87_503 vssd1 vssd1 vccd1 vccd1 sky130_fd_sc_hd__fill_1
X_2577_ _2576_/A _2576_/B _4461_/Q vssd1 vssd1 vccd1 vccd1 _2578_/A sky130_fd_sc_hd__o21bai_1
X_4316_ _4316_/A _4328_/B _4328_/C vssd1 vssd1 vccd1 vccd1 _4316_/X sky130_fd_sc_hd__and3_1
X_4247_ _4313_/S _4305_/A1 _4314_/S vssd1 vssd1 vccd1 vccd1 _4247_/X sky130_fd_sc_hd__a21o_1
XANTENNA_fanout383_A fanout388/X vssd1 vssd1 vccd1 vccd1 sky130_fd_sc_hd__diode_2
X_4178_ _4313_/S _4179_/B _4179_/C _4178_/D vssd1 vssd1 vccd1 vccd1 _4178_/X sky130_fd_sc_hd__and4b_1
XANTENNA__2656__A2 _3870_/B1 vssd1 vssd1 vccd1 vccd1 sky130_fd_sc_hd__diode_2
X_3129_ _4785_/Q _4770_/Q _3150_/A vssd1 vssd1 vccd1 vccd1 _3132_/B sky130_fd_sc_hd__a21o_1
XTAP_TAPCELL_ROW_81_921 vssd1 vccd1 sky130_fd_sc_hd__tapvpwrvgnd_1
XANTENNA__2307__A _4005_/D vssd1 vssd1 vccd1 vccd1 sky130_fd_sc_hd__diode_2
XTAP_TAPCELL_ROW_53_667 vssd1 vccd1 sky130_fd_sc_hd__tapvpwrvgnd_1
XFILLER_50_193 vssd1 vssd1 vccd1 vccd1 sky130_fd_sc_hd__fill_1
XANTENNA__3908__A2 _3946_/A1 vssd1 vssd1 vccd1 vccd1 sky130_fd_sc_hd__diode_2
XFILLER_51_57 vssd1 vssd1 vccd1 vccd1 sky130_fd_sc_hd__fill_1
XANTENNA__3541__B1 _3541_/B1 vssd1 vssd1 vccd1 vccd1 sky130_fd_sc_hd__diode_2
XANTENNA__4333__A2 _4328_/C vssd1 vssd1 vccd1 vccd1 sky130_fd_sc_hd__diode_2
XANTENNA__4097__A1 _4231_/C vssd1 vssd1 vccd1 vccd1 sky130_fd_sc_hd__diode_2
XTAP_TAPCELL_ROW_16_336 vssd1 vccd1 sky130_fd_sc_hd__tapvpwrvgnd_1
XFILLER_26_190 vssd1 vssd1 vccd1 vccd1 sky130_fd_sc_hd__decap_6
XFILLER_33_138 vccd1 vssd1 vccd1 vssd1 sky130_ef_sc_hd__decap_12
X_3480_ _3474_/B _3474_/A _3475_/A _3481_/B vssd1 vssd1 vccd1 vccd1 _3480_/X sky130_fd_sc_hd__a211o_1
X_2500_ _2501_/A _2501_/B vssd1 vssd1 vccd1 vccd1 _2500_/Y sky130_fd_sc_hd__nand2_1
X_2431_ _4510_/Q _3806_/A2 _2430_/X vssd1 vssd1 vccd1 vccd1 _4510_/D sky130_fd_sc_hd__o21a_1
X_2362_ hold4/X _2361_/X _2382_/S vssd1 vssd1 vccd1 vccd1 _4476_/D sky130_fd_sc_hd__mux2_1
XFILLER_37_3 vssd1 vssd1 vccd1 vccd1 sky130_fd_sc_hd__decap_8
X_2293_ _4455_/Q _3983_/B2 _2291_/Y _2292_/X vssd1 vssd1 vccd1 vccd1 _4455_/D sky130_fd_sc_hd__o22a_1
XPHY_EDGE_ROW_16_Left_104 vssd1 vssd1 vccd1 vccd1 sky130_fd_sc_hd__decap_3
X_4101_ _4302_/D _4105_/A2 _4225_/B2 vssd1 vssd1 vccd1 vccd1 _4101_/Y sky130_fd_sc_hd__o21ai_1
X_4032_ _4036_/A0 _4036_/A1 _4037_/D vssd1 vssd1 vccd1 vccd1 _4032_/X sky130_fd_sc_hd__mux2_1
XFILLER_49_293 vssd1 vssd1 vccd1 vccd1 sky130_fd_sc_hd__decap_4
XFILLER_64_230 vccd1 vssd1 vccd1 vssd1 sky130_ef_sc_hd__decap_12
XFILLER_64_263 vccd1 vssd1 vccd1 vssd1 sky130_ef_sc_hd__decap_12
XPHY_EDGE_ROW_25_Left_113 vssd1 vssd1 vccd1 vccd1 sky130_fd_sc_hd__decap_3
XTAP_TAPCELL_ROW_50_637 vssd1 vccd1 sky130_fd_sc_hd__tapvpwrvgnd_1
X_4796_ _4815_/CLK _4796_/D fanout394/X vssd1 vssd1 vccd1 vccd1 _4796_/Q sky130_fd_sc_hd__dfrtp_1
X_3816_ _4626_/Q _3830_/A2 _2564_/X _3815_/Y vssd1 vssd1 vccd1 vccd1 _4626_/D sky130_fd_sc_hd__a22o_1
X_3747_ _3759_/A _3759_/B vssd1 vssd1 vccd1 vccd1 _3748_/B sky130_fd_sc_hd__nor2_1
XFILLER_20_377 vssd1 vssd1 vccd1 vccd1 sky130_fd_sc_hd__decap_3
XFILLER_20_388 vssd1 vssd1 vccd1 vccd1 sky130_fd_sc_hd__fill_1
X_3678_ _3727_/A _3660_/Y _3676_/Y vssd1 vssd1 vccd1 vccd1 _3679_/B sky130_fd_sc_hd__o21ai_1
X_2629_ _2629_/A _2629_/B _2629_/C vssd1 vssd1 vccd1 vccd1 _2632_/A sky130_fd_sc_hd__or3_1
XPHY_EDGE_ROW_34_Left_122 vssd1 vssd1 vccd1 vccd1 sky130_fd_sc_hd__decap_3
XFILLER_87_333 vssd1 vssd1 vccd1 vccd1 sky130_fd_sc_hd__decap_3
XFILLER_87_377 vssd1 vssd1 vccd1 vccd1 sky130_fd_sc_hd__decap_4
XANTENNA__4079__A1 _4083_/A1 vssd1 vssd1 vccd1 vccd1 sky130_fd_sc_hd__diode_2
XTAP_TAPCELL_ROW_58_715 vssd1 vccd1 sky130_fd_sc_hd__tapvpwrvgnd_1
XFILLER_87_399 vccd1 vssd1 vccd1 vssd1 sky130_ef_sc_hd__decap_12
XFILLER_70_211 vccd1 vssd1 vccd1 vssd1 sky130_ef_sc_hd__decap_12
XTAP_TAPCELL_ROW_66_781 vssd1 vccd1 sky130_fd_sc_hd__tapvpwrvgnd_1
XPHY_EDGE_ROW_43_Left_131 vssd1 vssd1 vccd1 vccd1 sky130_fd_sc_hd__decap_3
XFILLER_43_447 vssd1 vssd1 vccd1 vccd1 sky130_fd_sc_hd__fill_1
XTAP_TAPCELL_ROW_13_306 vssd1 vccd1 sky130_fd_sc_hd__tapvpwrvgnd_1
XANTENNA__4251__A1 _4313_/S vssd1 vssd1 vccd1 vccd1 sky130_fd_sc_hd__diode_2
XFILLER_7_359 vssd1 vssd1 vccd1 vccd1 sky130_fd_sc_hd__decap_3
XPHY_EDGE_ROW_52_Left_140 vssd1 vssd1 vccd1 vccd1 sky130_fd_sc_hd__decap_3
XFILLER_87_53 vssd1 vssd1 vccd1 vccd1 sky130_fd_sc_hd__decap_3
XFILLER_38_208 vssd1 vssd1 vccd1 vccd1 sky130_fd_sc_hd__decap_3
XFILLER_19_411 vssd1 vssd1 vccd1 vccd1 sky130_fd_sc_hd__decap_3
Xfanout390 fanout393/X vssd1 vssd1 vccd1 vccd1 fanout390/X sky130_fd_sc_hd__clkbuf_2
XTAP_TAPCELL_ROW_29_450 vssd1 vccd1 sky130_fd_sc_hd__tapvpwrvgnd_1
XFILLER_46_263 vssd1 vssd1 vccd1 vccd1 sky130_fd_sc_hd__decap_6
X_2980_ _2978_/A _2978_/B _2979_/A vssd1 vssd1 vccd1 vccd1 _2980_/X sky130_fd_sc_hd__o21a_1
XANTENNA__3985__B _4001_/B vssd1 vssd1 vccd1 vccd1 sky130_fd_sc_hd__diode_2
XFILLER_61_288 vccd1 vssd1 vccd1 vssd1 sky130_ef_sc_hd__decap_12
X_4650_ _4669_/CLK _4650_/D fanout406/X vssd1 vssd1 vccd1 vccd1 hold96/A sky130_fd_sc_hd__dfrtp_1
Xinput21 s_axis_tdata[26] vssd1 vssd1 vccd1 vccd1 input21/X sky130_fd_sc_hd__clkbuf_1
Xinput10 s_axis_tdata[16] vssd1 vssd1 vccd1 vccd1 input10/X sky130_fd_sc_hd__clkbuf_1
X_3601_ _3627_/A _3608_/B vssd1 vssd1 vccd1 vccd1 _3602_/B sky130_fd_sc_hd__nor2_1
Xinput32 s_axis_tdata[7] vssd1 vssd1 vccd1 vccd1 input32/X sky130_fd_sc_hd__clkbuf_1
X_4581_ _4667_/CLK _4581_/D fanout412/X vssd1 vssd1 vccd1 vccd1 _4581_/Q sky130_fd_sc_hd__dfrtp_4
X_3532_ _3531_/A _3531_/C _3531_/B vssd1 vssd1 vccd1 vccd1 _3532_/X sky130_fd_sc_hd__a21o_1
XANTENNA__2308__A1 _4005_/D vssd1 vssd1 vccd1 vccd1 sky130_fd_sc_hd__diode_2
X_3463_ _3463_/A _3463_/B vssd1 vssd1 vccd1 vccd1 _3463_/Y sky130_fd_sc_hd__nand2_1
X_2414_ hold84/X _2413_/X _2420_/S vssd1 vssd1 vccd1 vccd1 _4502_/D sky130_fd_sc_hd__mux2_1
X_3394_ _3423_/A1 _3393_/Y _3423_/B1 vssd1 vssd1 vccd1 vccd1 _3394_/X sky130_fd_sc_hd__a21o_1
X_2345_ _4540_/Q input1/X vssd1 vssd1 vccd1 vccd1 _3158_/B sky130_fd_sc_hd__nand2_1
X_2276_ _4806_/Q _3873_/A vssd1 vssd1 vccd1 vccd1 _2340_/B sky130_fd_sc_hd__nor2_1
X_4015_ _4014_/Y _4013_/X _4012_/X hold97/X _4015_/B2 vssd1 vssd1 vccd1 vccd1 _4695_/D
+ sky130_fd_sc_hd__o32a_1
XFILLER_37_285 vssd1 vssd1 vccd1 vccd1 sky130_fd_sc_hd__fill_1
XANTENNA__4056__B _4119_/S vssd1 vssd1 vccd1 vccd1 sky130_fd_sc_hd__diode_2
XANTENNA_fanout346_A _4316_/A vssd1 vssd1 vccd1 vccd1 sky130_fd_sc_hd__diode_2
XFILLER_12_119 vssd1 vssd1 vccd1 vccd1 sky130_fd_sc_hd__fill_1
XANTENNA__3992__A0 _4020_/A0 vssd1 vssd1 vccd1 vccd1 sky130_fd_sc_hd__diode_2
XFILLER_20_130 vssd1 vssd1 vccd1 vccd1 sky130_fd_sc_hd__decap_8
XFILLER_20_141 vccd1 vssd1 vccd1 vssd1 sky130_ef_sc_hd__decap_12
X_4779_ _4780_/CLK _4779_/D fanout402/X vssd1 vssd1 vccd1 vccd1 _4779_/Q sky130_fd_sc_hd__dfrtp_2
XFILLER_4_307 vssd1 vssd1 vccd1 vccd1 sky130_fd_sc_hd__fill_1
XFILLER_73_55 vssd1 vssd1 vccd1 vccd1 sky130_fd_sc_hd__fill_1
XFILLER_73_33 vssd1 vssd1 vccd1 vccd1 sky130_fd_sc_hd__fill_1
XTAP_TAPCELL_ROW_26_420 vssd1 vccd1 sky130_fd_sc_hd__tapvpwrvgnd_1
XFILLER_28_296 vccd1 vssd1 vccd1 vssd1 sky130_ef_sc_hd__decap_12
XANTENNA__4224__A1 _4223_/C vssd1 vssd1 vccd1 vccd1 sky130_fd_sc_hd__diode_2
XANTENNA__4132__D _4266_/D vssd1 vssd1 vccd1 vccd1 sky130_fd_sc_hd__diode_2
XPHY_EDGE_ROW_5_Left_93 vssd1 vssd1 vccd1 vccd1 sky130_fd_sc_hd__decap_3
XFILLER_78_141 vssd1 vssd1 vccd1 vccd1 sky130_fd_sc_hd__decap_6
XFILLER_66_369 vssd1 vssd1 vccd1 vccd1 sky130_fd_sc_hd__decap_8
XFILLER_22_417 vssd1 vssd1 vccd1 vccd1 sky130_fd_sc_hd__decap_3
X_2963_ _3049_/B _4750_/Q vssd1 vssd1 vccd1 vccd1 _2964_/A sky130_fd_sc_hd__nor2_1
XTAP_TAPCELL_ROW_60_732 vssd1 vccd1 sky130_fd_sc_hd__tapvpwrvgnd_1
X_4702_ _4702_/CLK _4702_/D fanout387/X vssd1 vssd1 vccd1 vccd1 _4702_/Q sky130_fd_sc_hd__dfrtp_2
XTAP_TAPCELL_ROW_32_478 vssd1 vccd1 sky130_fd_sc_hd__tapvpwrvgnd_1
X_2894_ _2895_/B _2895_/C vssd1 vssd1 vccd1 vccd1 _2896_/B sky130_fd_sc_hd__nor2_1
X_4633_ _4667_/CLK _4633_/D fanout411/X vssd1 vssd1 vccd1 vccd1 _4633_/Q sky130_fd_sc_hd__dfrtp_1
X_4564_ _4605_/CLK _4564_/D fanout435/X vssd1 vssd1 vccd1 vccd1 _4564_/Q sky130_fd_sc_hd__dfrtp_2
X_3515_ _3511_/A _3511_/B _3511_/C _3308_/B _4573_/Q vssd1 vssd1 vccd1 vccd1 _3516_/B
+ sky130_fd_sc_hd__a32o_1
X_4495_ _4579_/CLK _4495_/D fanout433/X vssd1 vssd1 vccd1 vccd1 hold49/A sky130_fd_sc_hd__dfrtp_1
X_3446_ _3442_/A _3442_/B _3202_/A vssd1 vssd1 vccd1 vccd1 _3447_/B sky130_fd_sc_hd__o21bai_1
XANTENNA__4151__A0 _4171_/A0 vssd1 vssd1 vccd1 vccd1 sky130_fd_sc_hd__diode_2
XANTENNA_fanout296_A _4803_/Q vssd1 vssd1 vccd1 vccd1 sky130_fd_sc_hd__diode_2
X_3377_ _3383_/A1 _3380_/B _3376_/X _3383_/B1 vssd1 vssd1 vccd1 vccd1 _3377_/X sky130_fd_sc_hd__a31o_1
XFILLER_69_185 vccd1 vssd1 vccd1 vssd1 sky130_ef_sc_hd__decap_12
X_2328_ _4087_/S _2323_/B _4015_/B2 vssd1 vssd1 vccd1 vccd1 _2328_/Y sky130_fd_sc_hd__o21ai_1
X_2259_ hold19/X _4567_/Q _2270_/S vssd1 vssd1 vccd1 vccd1 _4438_/D sky130_fd_sc_hd__mux2_1
XFILLER_25_222 vssd1 vssd1 vccd1 vccd1 sky130_fd_sc_hd__fill_2
XANTENNA__4206__A1 _4210_/A1 vssd1 vssd1 vccd1 vccd1 sky130_fd_sc_hd__diode_2
XANTENNA__2315__A _4075_/S vssd1 vssd1 vccd1 vccd1 sky130_fd_sc_hd__diode_2
XANTENNA__4390__A0 _4227_/C vssd1 vssd1 vccd1 vccd1 sky130_fd_sc_hd__diode_2
XFILLER_0_321 vssd1 vssd1 vccd1 vccd1 sky130_fd_sc_hd__decap_4
XFILLER_75_111 vssd1 vssd1 vccd1 vccd1 sky130_fd_sc_hd__fill_1
XFILLER_0_365 vccd1 vssd1 vccd1 vssd1 sky130_ef_sc_hd__decap_12
XANTENNA_input24_A s_axis_tdata[29] vssd1 vssd1 vccd1 vccd1 sky130_fd_sc_hd__diode_2
XFILLER_48_358 vssd1 vssd1 vccd1 vccd1 sky130_fd_sc_hd__decap_6
XFILLER_84_65 vssd1 vssd1 vccd1 vccd1 sky130_fd_sc_hd__decap_4
XFILLER_75_177 vccd1 vssd1 vccd1 vssd1 sky130_ef_sc_hd__decap_12
XFILLER_84_87 vssd1 vssd1 vccd1 vccd1 sky130_fd_sc_hd__fill_1
XTAP_TAPCELL_ROW_74_857 vssd1 vccd1 sky130_fd_sc_hd__tapvpwrvgnd_1
XFILLER_56_380 vssd1 vssd1 vccd1 vccd1 sky130_fd_sc_hd__fill_2
XFILLER_16_266 vssd1 vssd1 vccd1 vccd1 sky130_fd_sc_hd__decap_8
XFILLER_71_383 vssd1 vssd1 vccd1 vccd1 sky130_fd_sc_hd__decap_8
XFILLER_8_421 vssd1 vssd1 vccd1 vccd1 sky130_fd_sc_hd__decap_3
XANTENNA__3420__A2 _3425_/A2 vssd1 vssd1 vccd1 vccd1 sky130_fd_sc_hd__diode_2
XANTENNA__4381__A0 _4119_/S vssd1 vssd1 vccd1 vccd1 sky130_fd_sc_hd__diode_2
X_3300_ _3301_/A _3301_/C _3463_/B vssd1 vssd1 vccd1 vccd1 _3300_/X sky130_fd_sc_hd__or3_1
X_4280_ _4279_/Y _4278_/X _4277_/X hold203/X _4280_/B2 vssd1 vssd1 vccd1 vccd1 _4762_/D
+ sky130_fd_sc_hd__o32a_1
XFILLER_79_461 vccd1 vssd1 vccd1 vssd1 sky130_ef_sc_hd__decap_12
X_3231_ _3231_/A _3231_/B vssd1 vssd1 vccd1 vccd1 _3398_/A sky130_fd_sc_hd__and2_1
X_3162_ _3925_/S _3162_/B vssd1 vssd1 vccd1 vccd1 _3162_/Y sky130_fd_sc_hd__nand2_1
XFILLER_39_325 vssd1 vssd1 vccd1 vccd1 sky130_fd_sc_hd__decap_8
XFILLER_66_133 vssd1 vssd1 vccd1 vccd1 sky130_fd_sc_hd__fill_1
X_3093_ _3091_/X _3092_/Y _3078_/X _3157_/A2 vssd1 vssd1 vccd1 vccd1 _3094_/A sky130_fd_sc_hd__o31a_1
XTAP_TAPCELL_ROW_37_526 vssd1 vccd1 sky130_fd_sc_hd__tapvpwrvgnd_1
XFILLER_54_339 vssd1 vssd1 vccd1 vccd1 sky130_fd_sc_hd__fill_2
XANTENNA__4037__D _4037_/D vssd1 vssd1 vccd1 vccd1 sky130_fd_sc_hd__diode_2
X_3995_ _3994_/Y _3993_/X _3992_/X hold157/X _3995_/B2 vssd1 vssd1 vccd1 vccd1 _4690_/D
+ sky130_fd_sc_hd__o32a_1
XANTENNA__3947__B1 _4005_/D vssd1 vssd1 vccd1 vccd1 sky130_fd_sc_hd__diode_2
XTAP_TAPCELL_ROW_45_592 vssd1 vccd1 sky130_fd_sc_hd__tapvpwrvgnd_1
X_2946_ _2922_/B _2975_/A _2924_/X vssd1 vssd1 vccd1 vccd1 _2953_/A sky130_fd_sc_hd__a21oi_1
X_2877_ _2873_/A _3862_/B _2922_/B _2876_/B vssd1 vssd1 vccd1 vccd1 _2877_/X sky130_fd_sc_hd__o2bb2a_1
XANTENNA__3665__S _3741_/S vssd1 vssd1 vccd1 vccd1 sky130_fd_sc_hd__diode_2
X_4616_ _4669_/CLK _4616_/D fanout408/X vssd1 vssd1 vccd1 vccd1 _4616_/Q sky130_fd_sc_hd__dfrtp_1
XANTENNA_fanout309_A _4799_/Q vssd1 vssd1 vccd1 vccd1 sky130_fd_sc_hd__diode_2
X_4547_ _4553_/CLK _4547_/D fanout417/X vssd1 vssd1 vccd1 vccd1 _4547_/Q sky130_fd_sc_hd__dfrtp_4
X_4478_ _4546_/CLK _4478_/D fanout418/X vssd1 vssd1 vccd1 vccd1 hold16/A sky130_fd_sc_hd__dfrtp_1
X_3429_ _4599_/Q _3794_/A0 _3162_/B _4377_/C1 vssd1 vssd1 vccd1 vccd1 _3429_/X sky130_fd_sc_hd__o211a_1
XANTENNA_fanout299_X _4372_/A vssd1 vssd1 vccd1 vccd1 sky130_fd_sc_hd__diode_2
XANTENNA__3478__A2 _3522_/A2 vssd1 vssd1 vccd1 vccd1 sky130_fd_sc_hd__diode_2
XFILLER_57_111 vssd1 vssd1 vccd1 vccd1 sky130_fd_sc_hd__fill_1
XFILLER_38_47 vssd1 vssd1 vccd1 vccd1 sky130_fd_sc_hd__fill_1
XFILLER_57_133 vssd1 vssd1 vccd1 vccd1 sky130_fd_sc_hd__fill_1
XFILLER_60_309 vssd1 vssd1 vccd1 vccd1 sky130_fd_sc_hd__decap_8
XTAP_TAPCELL_ROW_71_827 vssd1 vccd1 sky130_fd_sc_hd__tapvpwrvgnd_1
XTAP_TAPCELL_ROW_0_184 vssd1 vccd1 sky130_fd_sc_hd__tapvpwrvgnd_1
XFILLER_54_79 vssd1 vssd1 vccd1 vccd1 sky130_fd_sc_hd__fill_1
XFILLER_13_236 vccd1 vssd1 vccd1 vssd1 sky130_ef_sc_hd__decap_12
XANTENNA__3938__A0 _3872_/X vssd1 vssd1 vccd1 vccd1 sky130_fd_sc_hd__diode_2
XFILLER_13_269 vssd1 vssd1 vccd1 vccd1 sky130_fd_sc_hd__decap_6
XFILLER_70_67 vssd1 vssd1 vccd1 vccd1 sky130_fd_sc_hd__decap_6
XFILLER_5_446 vssd1 vssd1 vccd1 vccd1 sky130_fd_sc_hd__fill_2
XTAP_TAPCELL_ROW_8_262 vssd1 vccd1 sky130_fd_sc_hd__tapvpwrvgnd_1
XANTENNA__4115__A0 _4167_/A0 vssd1 vssd1 vccd1 vccd1 sky130_fd_sc_hd__diode_2
XFILLER_0_195 vssd1 vssd1 vccd1 vccd1 sky130_fd_sc_hd__fill_1
XTAP_TAPCELL_ROW_87_982 vssd1 vccd1 sky130_fd_sc_hd__tapvpwrvgnd_1
XTAP_TAPCELL_ROW_87_971 vssd1 vccd1 sky130_fd_sc_hd__tapvpwrvgnd_1
XFILLER_29_391 vssd1 vssd1 vccd1 vccd1 sky130_fd_sc_hd__fill_1
XFILLER_63_169 vssd1 vssd1 vccd1 vccd1 sky130_fd_sc_hd__fill_1
XANTENNA__3929__A0 _3872_/X vssd1 vssd1 vccd1 vccd1 sky130_fd_sc_hd__diode_2
X_3780_ _3780_/A vssd1 vssd1 vccd1 vccd1 _3780_/Y sky130_fd_sc_hd__inv_2
X_2800_ _2869_/B _4700_/Q vssd1 vssd1 vccd1 vccd1 _2802_/C sky130_fd_sc_hd__nand2_1
XANTENNA_clkbuf_leaf_14_clk_A clkload1/A vssd1 vssd1 vccd1 vccd1 sky130_fd_sc_hd__diode_2
XANTENNA__3993__B _4001_/B vssd1 vssd1 vccd1 vccd1 sky130_fd_sc_hd__diode_2
X_2731_ _2770_/A _4698_/Q vssd1 vssd1 vccd1 vccd1 _2785_/B sky130_fd_sc_hd__nand2_1
XFILLER_8_251 vssd1 vssd1 vccd1 vccd1 sky130_fd_sc_hd__fill_1
X_4401_ _4068_/B input17/X _4402_/S vssd1 vssd1 vccd1 vccd1 _4810_/D sky130_fd_sc_hd__mux2_1
XFILLER_8_284 vccd1 vssd1 vccd1 vssd1 sky130_ef_sc_hd__decap_12
X_2662_ _4696_/Q _4683_/Q vssd1 vssd1 vccd1 vccd1 _2662_/X sky130_fd_sc_hd__and2_1
X_2593_ _2593_/A _2593_/B vssd1 vssd1 vccd1 vccd1 _2593_/X sky130_fd_sc_hd__or2_1
XANTENNA_clkbuf_leaf_29_clk_A clkbuf_2_3__f_clk/X vssd1 vssd1 vccd1 vccd1 sky130_fd_sc_hd__diode_2
X_4332_ _4332_/A _4344_/B vssd1 vssd1 vccd1 vccd1 _4332_/Y sky130_fd_sc_hd__nor2_1
Xfanout208 _3946_/A2 vssd1 vssd1 vccd1 vccd1 _3943_/A2 sky130_fd_sc_hd__buf_2
Xfanout219 _2228_/Y vssd1 vssd1 vccd1 vccd1 _4377_/C1 sky130_fd_sc_hd__buf_4
X_4263_ _4323_/S _4279_/A2 _4264_/B2 vssd1 vssd1 vccd1 vccd1 _4263_/Y sky130_fd_sc_hd__o21ai_1
X_3214_ _3213_/A _3213_/B _3203_/Y vssd1 vssd1 vccd1 vccd1 _3214_/X sky130_fd_sc_hd__o21ba_1
X_4194_ _4214_/A0 _4210_/A1 _4266_/D vssd1 vssd1 vccd1 vccd1 _4194_/X sky130_fd_sc_hd__mux2_1
X_3145_ _3145_/A _3145_/B vssd1 vssd1 vccd1 vccd1 _3147_/B sky130_fd_sc_hd__xor2_1
XFILLER_39_166 vssd1 vssd1 vccd1 vccd1 sky130_fd_sc_hd__fill_2
X_3076_ _3862_/C _3862_/D _3104_/A _3076_/D vssd1 vssd1 vccd1 vccd1 _3104_/B sky130_fd_sc_hd__nand4_2
XFILLER_39_199 vccd1 vssd1 vccd1 vssd1 sky130_ef_sc_hd__decap_12
XFILLER_82_489 vccd1 vssd1 vccd1 vssd1 sky130_ef_sc_hd__decap_12
XANTENNA_fanout161_A _2273_/X vssd1 vssd1 vccd1 vccd1 sky130_fd_sc_hd__diode_2
XANTENNA_fanout259_A _4815_/Q vssd1 vssd1 vccd1 vccd1 sky130_fd_sc_hd__diode_2
X_3978_ _3981_/D _4020_/A1 _3900_/B vssd1 vssd1 vccd1 vccd1 _3978_/X sky130_fd_sc_hd__a21o_1
X_2929_ _2916_/X _2928_/Y _2930_/A2 vssd1 vssd1 vccd1 vccd1 _2929_/Y sky130_fd_sc_hd__o21ai_1
XANTENNA__4345__B1 _4314_/S vssd1 vssd1 vccd1 vccd1 sky130_fd_sc_hd__diode_2
XFILLER_49_57 vssd1 vssd1 vccd1 vccd1 sky130_fd_sc_hd__fill_1
XTAP_TAPCELL_ROW_5_232 vssd1 vccd1 sky130_fd_sc_hd__tapvpwrvgnd_1
XTAP_TAPCELL_ROW_84_941 vssd1 vccd1 sky130_fd_sc_hd__tapvpwrvgnd_1
XFILLER_45_103 vssd1 vssd1 vccd1 vccd1 sky130_fd_sc_hd__decap_8
XFILLER_45_125 vssd1 vssd1 vccd1 vccd1 sky130_fd_sc_hd__decap_3
XTAP_TAPCELL_ROW_11_289 vssd1 vccd1 sky130_fd_sc_hd__tapvpwrvgnd_1
XFILLER_5_243 vssd1 vssd1 vccd1 vccd1 sky130_fd_sc_hd__fill_2
XFILLER_5_265 vssd1 vssd1 vccd1 vccd1 sky130_fd_sc_hd__fill_1
XANTENNA__4140__D _4274_/D vssd1 vssd1 vccd1 vccd1 sky130_fd_sc_hd__diode_2
XFILLER_1_493 vssd1 vssd1 vccd1 vccd1 sky130_fd_sc_hd__decap_8
XFILLER_49_431 vssd1 vssd1 vccd1 vccd1 sky130_fd_sc_hd__fill_1
Xinput8 s_axis_tdata[14] vssd1 vssd1 vccd1 vccd1 input8/X sky130_fd_sc_hd__clkbuf_1
XTAP_TAPCELL_ROW_47_610 vssd1 vccd1 sky130_fd_sc_hd__tapvpwrvgnd_1
XTAP_TAPCELL_ROW_19_356 vssd1 vccd1 sky130_fd_sc_hd__tapvpwrvgnd_1
X_3901_ hold105/X _3975_/S _3900_/X vssd1 vssd1 vccd1 vccd1 _4658_/D sky130_fd_sc_hd__a21bo_1
XFILLER_32_342 vssd1 vssd1 vccd1 vccd1 sky130_fd_sc_hd__fill_1
X_3832_ hold140/X _3848_/A2 _3831_/Y vssd1 vssd1 vccd1 vccd1 _4634_/D sky130_fd_sc_hd__a21o_1
X_3763_ _4534_/Q _4643_/Q _3761_/X _3762_/X vssd1 vssd1 vccd1 vccd1 _3764_/A sky130_fd_sc_hd__a22o_1
X_2714_ _4726_/Q _2673_/B _2672_/A vssd1 vssd1 vccd1 vccd1 _2717_/A sky130_fd_sc_hd__a21o_1
X_3694_ _3689_/Y _3691_/Y _3725_/A vssd1 vssd1 vccd1 vccd1 _3709_/A sky130_fd_sc_hd__o21bai_2
X_2645_ _4656_/Q _4754_/Q _2646_/A vssd1 vssd1 vccd1 vccd1 _2648_/B sky130_fd_sc_hd__a21o_1
X_2576_ _2576_/A _2576_/B _4461_/Q vssd1 vssd1 vccd1 vccd1 _2617_/D sky130_fd_sc_hd__or3b_2
X_4315_ _4339_/A0 _4343_/A1 _4320_/A vssd1 vssd1 vccd1 vccd1 _4315_/X sky130_fd_sc_hd__mux2_1
X_4246_ _4245_/D _4246_/B _4246_/C vssd1 vssd1 vccd1 vccd1 _4246_/X sky130_fd_sc_hd__and3b_1
X_4177_ _4736_/Q _4295_/B1 _4171_/X _4176_/Y vssd1 vssd1 vccd1 vccd1 _4736_/D sky130_fd_sc_hd__o22a_1
XFILLER_82_220 vccd1 vssd1 vccd1 vssd1 sky130_ef_sc_hd__decap_12
X_3128_ _3150_/A _3074_/A _3108_/Y vssd1 vssd1 vccd1 vccd1 _3134_/A sky130_fd_sc_hd__a21oi_1
XANTENNA_fanout376_A fanout379/X vssd1 vssd1 vccd1 vccd1 sky130_fd_sc_hd__diode_2
XANTENNA__2294__S _4332_/A vssd1 vssd1 vccd1 vccd1 sky130_fd_sc_hd__diode_2
XTAP_TAPCELL_ROW_81_922 vssd1 vccd1 sky130_fd_sc_hd__tapvpwrvgnd_1
X_3059_ _3025_/A _3024_/B _3024_/A vssd1 vssd1 vccd1 vccd1 _3063_/A sky130_fd_sc_hd__o21bai_1
XFILLER_70_448 vssd1 vssd1 vccd1 vccd1 sky130_fd_sc_hd__fill_1
XFILLER_70_437 vssd1 vssd1 vccd1 vccd1 sky130_fd_sc_hd__fill_1
XANTENNA__2307__B _2323_/B vssd1 vssd1 vccd1 vccd1 sky130_fd_sc_hd__diode_2
XANTENNA__2813__B1 _2812_/C vssd1 vssd1 vccd1 vccd1 sky130_fd_sc_hd__diode_2
XANTENNA_fanout331_X _4064_/D vssd1 vssd1 vccd1 vccd1 sky130_fd_sc_hd__diode_2
XTAP_TAPCELL_ROW_53_668 vssd1 vccd1 sky130_fd_sc_hd__tapvpwrvgnd_1
XFILLER_51_47 vssd1 vssd1 vccd1 vccd1 sky130_fd_sc_hd__fill_1
XANTENNA__4333__A3 _4328_/B vssd1 vssd1 vccd1 vccd1 sky130_fd_sc_hd__diode_2
XANTENNA__4097__A2 _4105_/A2 vssd1 vssd1 vccd1 vccd1 sky130_fd_sc_hd__diode_2
XFILLER_18_114 vssd1 vssd1 vccd1 vccd1 sky130_fd_sc_hd__decap_3
XFILLER_46_401 vssd1 vssd1 vccd1 vccd1 sky130_fd_sc_hd__decap_8
XFILLER_58_261 vssd1 vssd1 vccd1 vccd1 sky130_fd_sc_hd__fill_2
XFILLER_18_169 vssd1 vssd1 vccd1 vccd1 sky130_fd_sc_hd__fill_1
XTAP_TAPCELL_ROW_16_337 vssd1 vccd1 sky130_fd_sc_hd__tapvpwrvgnd_1
XANTENNA__3993__A_N _3976_/D vssd1 vssd1 vccd1 vccd1 sky130_fd_sc_hd__diode_2
X_2430_ _4658_/Q _4670_/Q _3795_/S vssd1 vssd1 vccd1 vccd1 _2430_/X sky130_fd_sc_hd__a21o_1
X_2361_ _3282_/A hold26/A _2369_/S vssd1 vssd1 vccd1 vccd1 _2361_/X sky130_fd_sc_hd__mux2_1
X_2292_ _4119_/S _2295_/C _2295_/B _3928_/S _2290_/X vssd1 vssd1 vccd1 vccd1 _2292_/X
+ sky130_fd_sc_hd__a311o_1
X_4100_ _4175_/C _4104_/B _4100_/C _4302_/D vssd1 vssd1 vccd1 vccd1 _4100_/X sky130_fd_sc_hd__and4b_1
X_4031_ _4030_/Y _4029_/X _4028_/X hold162/X _4038_/B1 vssd1 vssd1 vccd1 vccd1 _4699_/D
+ sky130_fd_sc_hd__o32a_1
XFILLER_2_85 vssd1 vssd1 vccd1 vccd1 sky130_fd_sc_hd__fill_1
XFILLER_49_261 vssd1 vssd1 vccd1 vccd1 sky130_fd_sc_hd__decap_3
XFILLER_49_272 vssd1 vssd1 vccd1 vccd1 sky130_fd_sc_hd__decap_3
XFILLER_64_242 vssd1 vssd1 vccd1 vccd1 sky130_fd_sc_hd__decap_8
XFILLER_64_275 vccd1 vssd1 vccd1 vssd1 sky130_ef_sc_hd__decap_12
XFILLER_64_253 vssd1 vssd1 vccd1 vccd1 sky130_fd_sc_hd__decap_3
XANTENNA__3938__S _4332_/A vssd1 vssd1 vccd1 vccd1 sky130_fd_sc_hd__diode_2
XFILLER_20_323 vssd1 vssd1 vccd1 vccd1 sky130_fd_sc_hd__decap_6
XTAP_TAPCELL_ROW_50_638 vssd1 vccd1 sky130_fd_sc_hd__tapvpwrvgnd_1
X_4795_ clkload3/A _4795_/D fanout376/X vssd1 vssd1 vccd1 vccd1 _4795_/Q sky130_fd_sc_hd__dfrtp_1
X_3815_ _3815_/A _3815_/B vssd1 vssd1 vccd1 vccd1 _3815_/Y sky130_fd_sc_hd__nand2_1
X_3746_ _4533_/Q _4642_/Q vssd1 vssd1 vccd1 vccd1 _3759_/B sky130_fd_sc_hd__nor2_1
XANTENNA_fanout124_A _3975_/S vssd1 vssd1 vccd1 vccd1 sky130_fd_sc_hd__diode_2
X_3677_ _3690_/B _3690_/C _3690_/A vssd1 vssd1 vccd1 vccd1 _3727_/A sky130_fd_sc_hd__or3_1
X_2628_ hold97/A _4682_/Q vssd1 vssd1 vccd1 vccd1 _2629_/A sky130_fd_sc_hd__nor2_1
X_2559_ _2590_/A _2559_/B vssd1 vssd1 vccd1 vccd1 _2560_/B sky130_fd_sc_hd__nor2_1
XFILLER_75_518 vssd1 vssd1 vccd1 vccd1 sky130_fd_sc_hd__fill_1
X_4229_ _4228_/Y _4227_/X _4226_/X hold109/X _4240_/B1 vssd1 vssd1 vccd1 vccd1 _4749_/D
+ sky130_fd_sc_hd__o32a_1
XANTENNA_fanout379_X fanout379/X vssd1 vssd1 vccd1 vccd1 sky130_fd_sc_hd__diode_2
XFILLER_28_401 vssd1 vssd1 vccd1 vccd1 sky130_fd_sc_hd__decap_8
XANTENNA__3826__A2 _3828_/A2 vssd1 vssd1 vccd1 vccd1 sky130_fd_sc_hd__diode_2
XTAP_TAPCELL_ROW_66_782 vssd1 vccd1 sky130_fd_sc_hd__tapvpwrvgnd_1
XTAP_TAPCELL_ROW_13_307 vssd1 vccd1 sky130_fd_sc_hd__tapvpwrvgnd_1
XFILLER_51_481 vssd1 vssd1 vccd1 vccd1 sky130_fd_sc_hd__decap_6
XFILLER_87_76 vssd1 vssd1 vccd1 vccd1 sky130_fd_sc_hd__fill_2
XFILLER_87_98 vssd1 vssd1 vccd1 vccd1 sky130_fd_sc_hd__fill_1
Xfanout380 fanout382/X vssd1 vssd1 vccd1 vccd1 fanout380/X sky130_fd_sc_hd__clkbuf_4
Xfanout391 fanout393/X vssd1 vssd1 vccd1 vccd1 fanout391/X sky130_fd_sc_hd__clkbuf_4
XFILLER_19_445 vssd1 vssd1 vccd1 vccd1 sky130_fd_sc_hd__fill_1
XTAP_TAPCELL_ROW_29_451 vssd1 vccd1 sky130_fd_sc_hd__tapvpwrvgnd_1
XFILLER_61_223 vssd1 vssd1 vccd1 vccd1 sky130_fd_sc_hd__fill_1
XFILLER_61_212 vssd1 vssd1 vccd1 vccd1 sky130_fd_sc_hd__fill_1
XFILLER_34_426 vssd1 vssd1 vccd1 vccd1 sky130_fd_sc_hd__decap_4
XFILLER_14_150 vssd1 vssd1 vccd1 vccd1 sky130_fd_sc_hd__decap_6
XANTENNA__3985__C _4033_/C vssd1 vssd1 vccd1 vccd1 sky130_fd_sc_hd__diode_2
XANTENNA__4021__A_N _4104_/C vssd1 vssd1 vccd1 vccd1 sky130_fd_sc_hd__diode_2
Xinput22 s_axis_tdata[27] vssd1 vssd1 vccd1 vccd1 input22/X sky130_fd_sc_hd__clkbuf_1
Xinput11 s_axis_tdata[17] vssd1 vssd1 vccd1 vccd1 input11/X sky130_fd_sc_hd__clkbuf_1
X_3600_ _4516_/Q _4625_/Q vssd1 vssd1 vccd1 vccd1 _3608_/B sky130_fd_sc_hd__nor2_1
X_4580_ _4580_/CLK _4580_/D fanout433/X vssd1 vssd1 vccd1 vccd1 _4580_/Q sky130_fd_sc_hd__dfrtp_4
X_3531_ _3531_/A _3531_/B _3531_/C vssd1 vssd1 vccd1 vccd1 _3531_/Y sky130_fd_sc_hd__nand3_1
Xinput33 s_axis_tdata[8] vssd1 vssd1 vccd1 vccd1 input33/X sky130_fd_sc_hd__clkbuf_1
X_3462_ _3460_/Y _3461_/Y _4564_/Q _3540_/B2 vssd1 vssd1 vccd1 vccd1 _4564_/D sky130_fd_sc_hd__a2bb2o_1
X_2413_ _4574_/Q hold50/A _2419_/S vssd1 vssd1 vccd1 vccd1 _2413_/X sky130_fd_sc_hd__mux2_1
X_3393_ _3393_/A _3393_/B vssd1 vssd1 vccd1 vccd1 _3393_/Y sky130_fd_sc_hd__xnor2_1
XFILLER_69_334 vssd1 vssd1 vccd1 vccd1 sky130_fd_sc_hd__fill_2
X_2344_ _2340_/X _2343_/X _4468_/Q _3979_/A2 vssd1 vssd1 vccd1 vccd1 _4468_/D sky130_fd_sc_hd__o2bb2a_1
XANTENNA__3808__A2 _3828_/A2 vssd1 vssd1 vccd1 vccd1 sky130_fd_sc_hd__diode_2
X_2275_ _4806_/Q _3873_/A vssd1 vssd1 vccd1 vccd1 _2275_/X sky130_fd_sc_hd__and2_1
X_4014_ _4075_/S _4038_/A2 _4015_/B2 vssd1 vssd1 vccd1 vccd1 _4014_/Y sky130_fd_sc_hd__o21ai_1
XTAP_TAPCELL_ROW_63_752 vssd1 vccd1 sky130_fd_sc_hd__tapvpwrvgnd_1
XANTENNA_fanout339_A _4253_/S vssd1 vssd1 vccd1 vccd1 sky130_fd_sc_hd__diode_2
XANTENNA__3992__A1 _4020_/A1 vssd1 vssd1 vccd1 vccd1 sky130_fd_sc_hd__diode_2
XANTENNA__4072__B _4810_/Q vssd1 vssd1 vccd1 vccd1 sky130_fd_sc_hd__diode_2
XFILLER_20_153 vccd1 vssd1 vccd1 vssd1 sky130_ef_sc_hd__decap_12
XANTENNA_fanout127_X _4361_/B1 vssd1 vssd1 vccd1 vccd1 sky130_fd_sc_hd__diode_2
X_4778_ _4780_/CLK _4778_/D fanout400/X vssd1 vssd1 vccd1 vccd1 _4778_/Q sky130_fd_sc_hd__dfrtp_1
X_3729_ _3729_/A _3729_/B _3729_/C _3716_/Y vssd1 vssd1 vccd1 vccd1 _3729_/X sky130_fd_sc_hd__or4b_1
XFILLER_57_35 vssd1 vssd1 vccd1 vccd1 sky130_fd_sc_hd__fill_1
XFILLER_75_337 vccd1 vssd1 vccd1 vssd1 sky130_ef_sc_hd__decap_12
XFILLER_75_315 vccd1 vssd1 vccd1 vssd1 sky130_ef_sc_hd__decap_12
XFILLER_87_197 vccd1 vssd1 vccd1 vssd1 sky130_ef_sc_hd__decap_12
XTAP_TAPCELL_ROW_26_421 vssd1 vccd1 sky130_fd_sc_hd__tapvpwrvgnd_1
XFILLER_11_131 vssd1 vssd1 vccd1 vccd1 sky130_fd_sc_hd__fill_1
XFILLER_11_175 vssd1 vssd1 vccd1 vccd1 sky130_fd_sc_hd__fill_1
XANTENNA__4202__S _4340_/A vssd1 vssd1 vccd1 vccd1 sky130_fd_sc_hd__diode_2
XFILLER_14_6 vssd1 vssd1 vccd1 vccd1 sky130_fd_sc_hd__fill_1
XFILLER_81_329 vssd1 vssd1 vccd1 vccd1 sky130_fd_sc_hd__fill_1
XFILLER_19_264 vssd1 vssd1 vccd1 vccd1 sky130_fd_sc_hd__fill_1
X_2962_ _3049_/B _4750_/Q vssd1 vssd1 vccd1 vccd1 _2964_/C sky130_fd_sc_hd__and2_1
X_4701_ _4702_/CLK _4701_/D fanout387/X vssd1 vssd1 vccd1 vccd1 _4701_/Q sky130_fd_sc_hd__dfrtp_1
XTAP_TAPCELL_ROW_60_733 vssd1 vccd1 sky130_fd_sc_hd__tapvpwrvgnd_1
XTAP_TAPCELL_ROW_32_479 vssd1 vccd1 sky130_fd_sc_hd__tapvpwrvgnd_1
X_4632_ _4667_/CLK _4632_/D fanout411/X vssd1 vssd1 vccd1 vccd1 _4632_/Q sky130_fd_sc_hd__dfrtp_1
X_2893_ _2893_/A _2893_/B _2893_/C vssd1 vssd1 vccd1 vccd1 _2893_/Y sky130_fd_sc_hd__nand3_1
X_4563_ _4635_/CLK _4563_/D fanout426/X vssd1 vssd1 vccd1 vccd1 _4563_/Q sky130_fd_sc_hd__dfrtp_2
X_3514_ _4573_/Q _3522_/A2 _3513_/X _3503_/X vssd1 vssd1 vccd1 vccd1 _4573_/D sky130_fd_sc_hd__a22o_1
X_4494_ _4579_/CLK _4494_/D fanout433/X vssd1 vssd1 vccd1 vccd1 hold8/A sky130_fd_sc_hd__dfrtp_1
X_3445_ _4561_/Q _3540_/B2 _3443_/X _3444_/X vssd1 vssd1 vccd1 vccd1 _4561_/D sky130_fd_sc_hd__a22o_1
XANTENNA__4151__A1 _4167_/A1 vssd1 vssd1 vccd1 vccd1 sky130_fd_sc_hd__diode_2
X_3376_ _3278_/X _3370_/D _3284_/D vssd1 vssd1 vccd1 vccd1 _3376_/X sky130_fd_sc_hd__a21o_1
XPHY_EDGE_ROW_71_Left_159 vssd1 vssd1 vccd1 vccd1 sky130_fd_sc_hd__decap_3
XTAP_TAPCELL_ROW_68_800 vssd1 vccd1 sky130_fd_sc_hd__tapvpwrvgnd_1
X_2327_ _4087_/S _2335_/B _2335_/C vssd1 vssd1 vccd1 vccd1 _2327_/X sky130_fd_sc_hd__and3_1
XFILLER_69_197 vssd1 vssd1 vccd1 vccd1 sky130_fd_sc_hd__decap_4
XANTENNA_fanout289_A _4001_/B vssd1 vssd1 vccd1 vccd1 sky130_fd_sc_hd__diode_2
X_2258_ hold41/X hold228/X _2272_/S vssd1 vssd1 vccd1 vccd1 _4437_/D sky130_fd_sc_hd__mux2_1
XFILLER_25_201 vssd1 vssd1 vccd1 vccd1 sky130_fd_sc_hd__decap_4
XANTENNA_fanout244_X _2365_/S vssd1 vssd1 vccd1 vccd1 sky130_fd_sc_hd__diode_2
XANTENNA__3414__B1 _3541_/B1 vssd1 vssd1 vccd1 vccd1 sky130_fd_sc_hd__diode_2
XPHY_EDGE_ROW_80_Left_168 vssd1 vssd1 vccd1 vccd1 sky130_fd_sc_hd__decap_3
XANTENNA__2315__B _2323_/B vssd1 vssd1 vccd1 vccd1 sky130_fd_sc_hd__diode_2
XFILLER_0_377 vccd1 vssd1 vccd1 vssd1 sky130_ef_sc_hd__decap_12
XFILLER_0_399 vccd1 vssd1 vccd1 vssd1 sky130_ef_sc_hd__decap_12
XFILLER_48_348 vssd1 vssd1 vccd1 vccd1 sky130_fd_sc_hd__fill_1
XANTENNA_input17_A s_axis_tdata[22] vssd1 vssd1 vccd1 vccd1 sky130_fd_sc_hd__diode_2
XFILLER_84_77 vssd1 vssd1 vccd1 vccd1 sky130_fd_sc_hd__fill_1
XFILLER_75_189 vssd1 vssd1 vccd1 vccd1 sky130_fd_sc_hd__decap_3
XTAP_TAPCELL_ROW_74_858 vssd1 vccd1 sky130_fd_sc_hd__tapvpwrvgnd_1
XANTENNA__3956__A1 _3873_/Y vssd1 vssd1 vccd1 vccd1 sky130_fd_sc_hd__diode_2
XFILLER_8_444 vssd1 vssd1 vccd1 vccd1 sky130_fd_sc_hd__fill_1
XFILLER_8_477 vssd1 vssd1 vccd1 vccd1 sky130_fd_sc_hd__decap_8
X_3230_ _4594_/Q _4553_/Q vssd1 vssd1 vccd1 vccd1 _3231_/B sky130_fd_sc_hd__nand2b_1
XANTENNA__4133__A1 _4266_/D vssd1 vssd1 vccd1 vccd1 sky130_fd_sc_hd__diode_2
XFILLER_79_473 vssd1 vssd1 vccd1 vccd1 sky130_fd_sc_hd__decap_4
X_3161_ hold215/X _3160_/Y _2250_/S vssd1 vssd1 vccd1 vccd1 _4540_/D sky130_fd_sc_hd__a21o_1
XFILLER_39_337 vssd1 vssd1 vccd1 vccd1 sky130_fd_sc_hd__fill_2
X_3092_ _3066_/A _3066_/B _3104_/B _3077_/X _3067_/Y vssd1 vssd1 vccd1 vccd1 _3092_/Y
+ sky130_fd_sc_hd__a221oi_2
XFILLER_62_351 vssd1 vssd1 vccd1 vccd1 sky130_fd_sc_hd__decap_4
X_3994_ _3935_/S _4022_/A2 _3995_/B2 vssd1 vssd1 vccd1 vccd1 _3994_/Y sky130_fd_sc_hd__o21ai_1
XTAP_TAPCELL_ROW_45_593 vssd1 vccd1 sky130_fd_sc_hd__tapvpwrvgnd_1
X_2945_ _2914_/A _2913_/A _2913_/B _2907_/A vssd1 vssd1 vccd1 vccd1 _2954_/A sky130_fd_sc_hd__a31oi_2
XFILLER_13_29 vssd1 vssd1 vccd1 vccd1 sky130_fd_sc_hd__fill_1
X_2876_ _2922_/B _2876_/B _3074_/C vssd1 vssd1 vccd1 vccd1 _2917_/A sky130_fd_sc_hd__nor3_1
X_4615_ _4668_/CLK _4615_/D fanout419/X vssd1 vssd1 vccd1 vccd1 _4615_/Q sky130_fd_sc_hd__dfrtp_1
X_4546_ _4546_/CLK _4546_/D fanout417/X vssd1 vssd1 vccd1 vccd1 _4546_/Q sky130_fd_sc_hd__dfrtp_1
X_4477_ _4549_/CLK _4477_/D fanout415/X vssd1 vssd1 vccd1 vccd1 hold13/A sky130_fd_sc_hd__dfrtp_1
X_3428_ _3333_/Y _3427_/Y _3332_/Y vssd1 vssd1 vccd1 vccd1 _3428_/X sky130_fd_sc_hd__a21o_1
XANTENNA_input9_A s_axis_tdata[15] vssd1 vssd1 vccd1 vccd1 sky130_fd_sc_hd__diode_2
X_3359_ _3359_/A _3359_/B _3359_/C vssd1 vssd1 vccd1 vccd1 _3361_/A sky130_fd_sc_hd__and3_1
XANTENNA__3883__A0 _4099_/A0 vssd1 vssd1 vccd1 vccd1 sky130_fd_sc_hd__diode_2
XFILLER_57_167 vssd1 vssd1 vccd1 vccd1 sky130_fd_sc_hd__fill_1
XFILLER_26_510 vssd1 vssd1 vccd1 vccd1 sky130_fd_sc_hd__fill_1
XFILLER_57_189 vssd1 vssd1 vccd1 vccd1 sky130_fd_sc_hd__decap_8
XTAP_TAPCELL_ROW_71_828 vssd1 vccd1 sky130_fd_sc_hd__tapvpwrvgnd_1
XTAP_TAPCELL_ROW_0_185 vssd1 vccd1 sky130_fd_sc_hd__tapvpwrvgnd_1
XFILLER_13_248 vssd1 vssd1 vccd1 vccd1 sky130_fd_sc_hd__fill_1
XANTENNA__3938__A1 _3971_/A1 vssd1 vssd1 vccd1 vccd1 sky130_fd_sc_hd__diode_2
XFILLER_70_79 vssd1 vssd1 vccd1 vccd1 sky130_fd_sc_hd__fill_1
XFILLER_79_55 vssd1 vssd1 vccd1 vccd1 sky130_fd_sc_hd__fill_1
XTAP_TAPCELL_ROW_8_263 vssd1 vccd1 sky130_fd_sc_hd__tapvpwrvgnd_1
XANTENNA__4115__A1 _4171_/A1 vssd1 vssd1 vccd1 vccd1 sky130_fd_sc_hd__diode_2
XFILLER_0_141 vccd1 vssd1 vccd1 vssd1 sky130_ef_sc_hd__decap_12
XANTENNA__3874__A0 _3872_/X vssd1 vssd1 vccd1 vccd1 sky130_fd_sc_hd__diode_2
XTAP_TAPCELL_ROW_87_983 vssd1 vccd1 sky130_fd_sc_hd__tapvpwrvgnd_1
XTAP_TAPCELL_ROW_87_972 vssd1 vccd1 sky130_fd_sc_hd__tapvpwrvgnd_1
XFILLER_63_159 vssd1 vssd1 vccd1 vccd1 sky130_fd_sc_hd__fill_1
XANTENNA__3929__A1 _3971_/A1 vssd1 vssd1 vccd1 vccd1 sky130_fd_sc_hd__diode_2
XANTENNA__4051__A0 _4099_/A0 vssd1 vssd1 vccd1 vccd1 sky130_fd_sc_hd__diode_2
XTAP_TAPCELL_ROW_42_563 vssd1 vccd1 sky130_fd_sc_hd__tapvpwrvgnd_1
XANTENNA__3993__C _4001_/C vssd1 vssd1 vccd1 vccd1 sky130_fd_sc_hd__diode_2
X_2730_ _4758_/Q _4773_/Q vssd1 vssd1 vccd1 vccd1 _2730_/X sky130_fd_sc_hd__or2_1
X_2661_ _2657_/X _2659_/Y _4771_/Q vssd1 vssd1 vccd1 vccd1 _2668_/B sky130_fd_sc_hd__o21bai_1
XFILLER_8_296 vccd1 vssd1 vccd1 vssd1 sky130_ef_sc_hd__decap_12
X_4400_ _4056_/D input16/X _4400_/S vssd1 vssd1 vccd1 vccd1 _4809_/D sky130_fd_sc_hd__mux2_1
XFILLER_60_90 vccd1 vssd1 vccd1 vssd1 sky130_ef_sc_hd__decap_12
X_2592_ _2592_/A _2592_/B vssd1 vssd1 vccd1 vccd1 _2593_/B sky130_fd_sc_hd__nor2_1
X_4331_ _4339_/A0 _4343_/A1 _4336_/A vssd1 vssd1 vccd1 vccd1 _4331_/X sky130_fd_sc_hd__mux2_1
Xfanout209 _2274_/A vssd1 vssd1 vccd1 vccd1 _3946_/A2 sky130_fd_sc_hd__buf_2
X_4262_ _4286_/A_N _4282_/B _4270_/C _4323_/S vssd1 vssd1 vccd1 vccd1 _4262_/X sky130_fd_sc_hd__and4b_1
X_3213_ _3213_/A _3213_/B vssd1 vssd1 vccd1 vccd1 _3213_/X sky130_fd_sc_hd__or2_1
XFILLER_79_292 vccd1 vssd1 vccd1 vssd1 sky130_ef_sc_hd__decap_12
X_4193_ _4192_/Y _4191_/X _4190_/X hold103/X _4193_/B2 vssd1 vssd1 vccd1 vccd1 _4740_/D
+ sky130_fd_sc_hd__o32a_1
X_3144_ _3144_/A _3144_/B vssd1 vssd1 vccd1 vccd1 _3145_/B sky130_fd_sc_hd__xnor2_1
X_3075_ _3074_/A _3074_/B _3144_/A vssd1 vssd1 vccd1 vccd1 _3076_/D sky130_fd_sc_hd__o21ai_1
XANTENNA__4064__C _4064_/C vssd1 vssd1 vccd1 vccd1 sky130_fd_sc_hd__diode_2
XANTENNA_fanout154_A _4338_/A2 vssd1 vssd1 vccd1 vccd1 sky130_fd_sc_hd__diode_2
XFILLER_50_321 vccd1 vssd1 vccd1 vssd1 sky130_ef_sc_hd__decap_12
XFILLER_50_343 vccd1 vssd1 vccd1 vssd1 sky130_ef_sc_hd__decap_12
XFILLER_10_207 vssd1 vssd1 vccd1 vccd1 sky130_fd_sc_hd__fill_1
X_3977_ _3976_/D _3977_/B _3977_/C vssd1 vssd1 vccd1 vccd1 _3977_/X sky130_fd_sc_hd__and3b_1
XFILLER_50_365 vccd1 vssd1 vccd1 vssd1 sky130_ef_sc_hd__decap_12
XANTENNA_fanout321_A _2311_/A vssd1 vssd1 vccd1 vccd1 sky130_fd_sc_hd__diode_2
X_2928_ _2928_/A _2928_/B vssd1 vssd1 vccd1 vccd1 _2928_/Y sky130_fd_sc_hd__xnor2_1
XFILLER_40_38 vssd1 vssd1 vccd1 vccd1 sky130_fd_sc_hd__fill_1
XANTENNA__4080__B _4104_/B vssd1 vssd1 vccd1 vccd1 sky130_fd_sc_hd__diode_2
X_2859_ _2820_/X _2823_/B _2858_/Y vssd1 vssd1 vccd1 vccd1 _2861_/B sky130_fd_sc_hd__o21ai_2
X_4529_ _4640_/CLK _4529_/D fanout425/X vssd1 vssd1 vccd1 vccd1 _4529_/Q sky130_fd_sc_hd__dfrtp_1
XFILLER_77_207 vssd1 vssd1 vccd1 vccd1 sky130_fd_sc_hd__decap_8
XTAP_TAPCELL_ROW_5_233 vssd1 vccd1 sky130_fd_sc_hd__tapvpwrvgnd_1
XFILLER_65_24 vssd1 vssd1 vccd1 vccd1 sky130_fd_sc_hd__decap_3
XFILLER_65_57 vssd1 vssd1 vccd1 vccd1 sky130_fd_sc_hd__decap_3
XFILLER_18_329 vssd1 vssd1 vccd1 vccd1 sky130_fd_sc_hd__fill_1
XFILLER_58_498 vssd1 vssd1 vccd1 vccd1 sky130_fd_sc_hd__fill_1
XTAP_TAPCELL_ROW_84_942 vssd1 vccd1 sky130_fd_sc_hd__tapvpwrvgnd_1
XFILLER_60_129 vssd1 vssd1 vccd1 vccd1 sky130_fd_sc_hd__fill_1
XFILLER_81_67 vssd1 vssd1 vccd1 vccd1 sky130_fd_sc_hd__fill_1
XANTENNA_clkbuf_2_3__f_clk_A clkbuf_0_clk/X vssd1 vssd1 vccd1 vccd1 sky130_fd_sc_hd__diode_2
XFILLER_5_233 vssd1 vssd1 vccd1 vccd1 sky130_fd_sc_hd__fill_1
XFILLER_5_277 vssd1 vssd1 vccd1 vccd1 sky130_fd_sc_hd__decap_3
XANTENNA__4210__S _4215_/C vssd1 vssd1 vccd1 vccd1 sky130_fd_sc_hd__diode_2
XFILLER_49_421 vssd1 vssd1 vccd1 vccd1 sky130_fd_sc_hd__fill_2
XFILLER_49_476 vssd1 vssd1 vccd1 vccd1 sky130_fd_sc_hd__decap_6
Xinput9 s_axis_tdata[15] vssd1 vssd1 vccd1 vccd1 input9/X sky130_fd_sc_hd__clkbuf_1
XFILLER_36_115 vssd1 vssd1 vccd1 vccd1 sky130_fd_sc_hd__fill_1
XTAP_TAPCELL_ROW_47_611 vssd1 vccd1 sky130_fd_sc_hd__tapvpwrvgnd_1
XTAP_TAPCELL_ROW_19_357 vssd1 vccd1 sky130_fd_sc_hd__tapvpwrvgnd_1
XFILLER_72_490 vssd1 vssd1 vccd1 vccd1 sky130_fd_sc_hd__fill_2
X_3900_ _4804_/Q _3900_/B _3873_/A vssd1 vssd1 vccd1 vccd1 _3900_/X sky130_fd_sc_hd__or3b_2
X_3831_ _2816_/X _2830_/Y _2831_/Y vssd1 vssd1 vccd1 vccd1 _3831_/Y sky130_fd_sc_hd__a21oi_1
X_3762_ _4533_/Q _4642_/Q _4534_/Q _4643_/Q vssd1 vssd1 vccd1 vccd1 _3762_/X sky130_fd_sc_hd__o22a_1
XFILLER_32_376 vccd1 vssd1 vccd1 vssd1 sky130_ef_sc_hd__decap_12
X_2713_ _2674_/A _2674_/B _2669_/B vssd1 vssd1 vccd1 vccd1 _2722_/A sky130_fd_sc_hd__o21a_1
X_3693_ _4527_/Q _4636_/Q vssd1 vssd1 vccd1 vccd1 _3725_/A sky130_fd_sc_hd__xnor2_1
X_2644_ _2219_/Y _2604_/C _2604_/B vssd1 vssd1 vccd1 vccd1 _2646_/A sky130_fd_sc_hd__o21bai_1
X_2575_ _4693_/Q _4680_/Q vssd1 vssd1 vccd1 vccd1 _2576_/B sky130_fd_sc_hd__nor2_1
X_4314_ _4313_/X hold119/X _4314_/S vssd1 vssd1 vccd1 vccd1 _4771_/D sky130_fd_sc_hd__mux2_1
XFILLER_87_505 vccd1 vssd1 vccd1 vssd1 sky130_ef_sc_hd__decap_12
X_4245_ _4313_/S _4246_/B _4246_/C _4245_/D vssd1 vssd1 vccd1 vccd1 _4245_/X sky130_fd_sc_hd__and4b_1
X_4176_ _4238_/S _4176_/A2 _4175_/Y _4377_/B1 _4377_/C1 vssd1 vssd1 vccd1 vccd1 _4176_/Y
+ sky130_fd_sc_hd__o2111ai_1
XTAP_TAPCELL_ROW_2_203 vssd1 vccd1 sky130_fd_sc_hd__tapvpwrvgnd_1
X_3127_ _3144_/A _3130_/B _3098_/B _3101_/X vssd1 vssd1 vccd1 vccd1 _3135_/A sky130_fd_sc_hd__o31a_1
XANTENNA_fanout271_A _4813_/Q vssd1 vssd1 vccd1 vccd1 sky130_fd_sc_hd__diode_2
XFILLER_55_402 vssd1 vssd1 vccd1 vccd1 sky130_fd_sc_hd__decap_8
XFILLER_82_232 vssd1 vssd1 vccd1 vccd1 sky130_fd_sc_hd__decap_6
XFILLER_27_159 vssd1 vssd1 vccd1 vccd1 sky130_fd_sc_hd__decap_8
XFILLER_55_446 vssd1 vssd1 vccd1 vccd1 sky130_fd_sc_hd__fill_2
X_3058_ _4766_/Q _4781_/Q _3033_/A _3036_/B vssd1 vssd1 vccd1 vccd1 _3066_/A sky130_fd_sc_hd__a31o_1
XFILLER_70_416 vssd1 vssd1 vccd1 vccd1 sky130_fd_sc_hd__decap_4
XFILLER_82_298 vssd1 vssd1 vccd1 vccd1 sky130_fd_sc_hd__decap_3
XFILLER_23_332 vssd1 vssd1 vccd1 vccd1 sky130_fd_sc_hd__decap_4
XFILLER_35_192 vssd1 vssd1 vccd1 vccd1 sky130_fd_sc_hd__fill_1
XFILLER_23_343 vccd1 vssd1 vccd1 vssd1 sky130_ef_sc_hd__decap_12
XTAP_TAPCELL_ROW_53_669 vssd1 vccd1 sky130_fd_sc_hd__tapvpwrvgnd_1
XANTENNA__4799__Q _4799_/Q vssd1 vssd1 vccd1 vccd1 sky130_fd_sc_hd__diode_2
XANTENNA_fanout324_X _4274_/D vssd1 vssd1 vccd1 vccd1 sky130_fd_sc_hd__diode_2
XANTENNA__2323__B _2323_/B vssd1 vssd1 vccd1 vccd1 sky130_fd_sc_hd__diode_2
XANTENNA__3541__A2 _2369_/S vssd1 vssd1 vccd1 vccd1 sky130_fd_sc_hd__diode_2
XANTENNA_clkbuf_leaf_13_clk_A clkload1/A vssd1 vssd1 vccd1 vccd1 sky130_fd_sc_hd__diode_2
XFILLER_58_251 vssd1 vssd1 vccd1 vccd1 sky130_fd_sc_hd__fill_1
XFILLER_73_276 vssd1 vssd1 vccd1 vccd1 sky130_fd_sc_hd__decap_4
XFILLER_61_416 vssd1 vssd1 vccd1 vccd1 sky130_fd_sc_hd__decap_8
XANTENNA_clkbuf_leaf_28_clk_A clkbuf_2_3__f_clk/X vssd1 vssd1 vccd1 vccd1 sky130_fd_sc_hd__diode_2
XFILLER_54_490 vssd1 vssd1 vccd1 vccd1 sky130_fd_sc_hd__fill_1
XFILLER_14_365 vssd1 vssd1 vccd1 vccd1 sky130_fd_sc_hd__fill_1
XFILLER_14_354 vssd1 vssd1 vccd1 vccd1 sky130_fd_sc_hd__decap_8
XFILLER_41_81 vssd1 vssd1 vccd1 vccd1 sky130_fd_sc_hd__fill_2
XFILLER_69_505 vssd1 vssd1 vccd1 vccd1 sky130_fd_sc_hd__fill_1
X_2360_ hold76/X _2359_/X _2366_/S vssd1 vssd1 vccd1 vccd1 _4475_/D sky130_fd_sc_hd__mux2_1
X_2291_ _4119_/S _2338_/B vssd1 vssd1 vccd1 vccd1 _2291_/Y sky130_fd_sc_hd__nor2_1
XPHY_EDGE_ROW_10_Right_10 vssd1 vssd1 vccd1 vccd1 sky130_fd_sc_hd__decap_3
XFILLER_2_31 vccd1 vssd1 vccd1 vssd1 sky130_ef_sc_hd__decap_12
X_4030_ _4029_/D _4038_/A2 _4038_/B1 vssd1 vssd1 vccd1 vccd1 _4030_/Y sky130_fd_sc_hd__o21ai_1
XANTENNA__2395__S _2419_/S vssd1 vssd1 vccd1 vccd1 sky130_fd_sc_hd__diode_2
XFILLER_64_287 vccd1 vssd1 vccd1 vssd1 sky130_ef_sc_hd__decap_12
Xclkbuf_leaf_44_clk clkload2/A vssd1 vssd1 vccd1 vccd1 _4631_/CLK sky130_fd_sc_hd__clkbuf_8
XANTENNA__4115__S _4120_/D vssd1 vssd1 vccd1 vccd1 sky130_fd_sc_hd__diode_2
XTAP_TAPCELL_ROW_50_639 vssd1 vccd1 sky130_fd_sc_hd__tapvpwrvgnd_1
X_4794_ _4794_/CLK _4794_/D fanout376/X vssd1 vssd1 vccd1 vccd1 _4794_/Q sky130_fd_sc_hd__dfrtp_2
X_3814_ hold187/X _3795_/S _3813_/Y vssd1 vssd1 vccd1 vccd1 _4625_/D sky130_fd_sc_hd__a21o_1
XFILLER_32_195 vssd1 vssd1 vccd1 vccd1 sky130_fd_sc_hd__fill_1
X_3745_ _4533_/Q _4642_/Q vssd1 vssd1 vccd1 vccd1 _3759_/A sky130_fd_sc_hd__and2_1
XANTENNA_fanout117_A _2427_/X vssd1 vssd1 vccd1 vccd1 sky130_fd_sc_hd__diode_2
X_3676_ _4524_/Q _4633_/Q _3675_/X vssd1 vssd1 vccd1 vccd1 _3676_/Y sky130_fd_sc_hd__o21ai_1
X_2627_ hold97/A _4682_/Q vssd1 vssd1 vccd1 vccd1 _2629_/C sky130_fd_sc_hd__and2_1
X_2558_ _4721_/Q _4706_/Q _2557_/A vssd1 vssd1 vccd1 vccd1 _2559_/B sky130_fd_sc_hd__a21oi_1
X_2489_ _2489_/A _2489_/B vssd1 vssd1 vccd1 vccd1 _3809_/B sky130_fd_sc_hd__xor2_1
X_4228_ _4227_/C _4240_/A2 _4240_/B1 vssd1 vssd1 vccd1 vccd1 _4228_/Y sky130_fd_sc_hd__o21ai_1
XANTENNA__3542__X _3542_/X vssd1 vssd1 vccd1 vccd1 sky130_fd_sc_hd__diode_2
XFILLER_55_221 vssd1 vssd1 vccd1 vccd1 sky130_fd_sc_hd__decap_3
X_4159_ _4171_/A0 _4167_/A1 _4231_/C vssd1 vssd1 vccd1 vccd1 _4159_/X sky130_fd_sc_hd__mux2_1
XFILLER_43_405 vccd1 vssd1 vccd1 vssd1 sky130_ef_sc_hd__decap_12
XTAP_TAPCELL_ROW_66_783 vssd1 vccd1 sky130_fd_sc_hd__tapvpwrvgnd_1
XFILLER_62_25 vssd1 vssd1 vccd1 vccd1 sky130_fd_sc_hd__fill_1
Xclkbuf_leaf_35_clk clkload2/A vssd1 vssd1 vccd1 vccd1 _4668_/CLK sky130_fd_sc_hd__clkbuf_8
XTAP_TAPCELL_ROW_13_308 vssd1 vccd1 sky130_fd_sc_hd__tapvpwrvgnd_1
XTAP_TAPCELL_ROW_21_374 vssd1 vccd1 sky130_fd_sc_hd__tapvpwrvgnd_1
XFILLER_11_84 vssd1 vssd1 vccd1 vccd1 sky130_fd_sc_hd__fill_1
XANTENNA__3514__A2 _3522_/A2 vssd1 vssd1 vccd1 vccd1 sky130_fd_sc_hd__diode_2
Xfanout370 _3784_/B1 vssd1 vssd1 vccd1 vccd1 _3318_/B sky130_fd_sc_hd__buf_1
Xfanout381 fanout382/X vssd1 vssd1 vccd1 vccd1 fanout381/X sky130_fd_sc_hd__clkbuf_4
Xfanout392 fanout393/X vssd1 vssd1 vccd1 vccd1 fanout392/X sky130_fd_sc_hd__dlymetal6s2s_1
XFILLER_46_232 vccd1 vssd1 vccd1 vssd1 sky130_ef_sc_hd__decap_12
XTAP_TAPCELL_ROW_29_452 vssd1 vccd1 sky130_fd_sc_hd__tapvpwrvgnd_1
XANTENNA__2228__B _2369_/S vssd1 vssd1 vccd1 vccd1 sky130_fd_sc_hd__diode_2
Xclkbuf_leaf_26_clk clkbuf_2_3__f_clk/X vssd1 vssd1 vccd1 vccd1 _4576_/CLK sky130_fd_sc_hd__clkbuf_8
XFILLER_61_246 vssd1 vssd1 vccd1 vccd1 sky130_fd_sc_hd__decap_8
XFILLER_14_195 vssd1 vssd1 vccd1 vccd1 sky130_fd_sc_hd__fill_1
Xinput12 s_axis_tdata[18] vssd1 vssd1 vccd1 vccd1 input12/X sky130_fd_sc_hd__clkbuf_1
Xinput23 s_axis_tdata[28] vssd1 vssd1 vccd1 vccd1 input23/X sky130_fd_sc_hd__clkbuf_1
Xinput34 s_axis_tdata[9] vssd1 vssd1 vccd1 vccd1 input34/X sky130_fd_sc_hd__clkbuf_1
X_3530_ _4577_/Q _3534_/A2 _3529_/X _3503_/X vssd1 vssd1 vccd1 vccd1 _4577_/D sky130_fd_sc_hd__a22o_1
X_3461_ _4605_/Q _3504_/A2 _3477_/B1 _3923_/A vssd1 vssd1 vccd1 vccd1 _3461_/Y sky130_fd_sc_hd__o211ai_1
X_2412_ hold74/X _2411_/X _2420_/S vssd1 vssd1 vccd1 vccd1 _4501_/D sky130_fd_sc_hd__mux2_1
X_3392_ _3242_/Y _3386_/X _3242_/A vssd1 vssd1 vccd1 vccd1 _3393_/B sky130_fd_sc_hd__o21a_1
XFILLER_42_3 vccd1 vssd1 vccd1 vssd1 sky130_ef_sc_hd__decap_12
XFILLER_69_324 vssd1 vssd1 vccd1 vccd1 sky130_fd_sc_hd__decap_4
X_2343_ _4036_/S _2335_/C _2335_/B _3946_/A1 _3946_/A2 vssd1 vssd1 vccd1 vccd1 _2343_/X
+ sky130_fd_sc_hd__o311a_1
XFILLER_69_346 vccd1 vssd1 vccd1 vssd1 sky130_ef_sc_hd__decap_12
X_2274_ _2274_/A _2274_/B vssd1 vssd1 vccd1 vccd1 _2274_/Y sky130_fd_sc_hd__nand2_1
X_4013_ _4100_/C _4037_/B _4037_/C _4075_/S vssd1 vssd1 vccd1 vccd1 _4013_/X sky130_fd_sc_hd__and4b_1
XFILLER_37_221 vssd1 vssd1 vccd1 vccd1 sky130_fd_sc_hd__decap_3
XFILLER_25_438 vssd1 vssd1 vccd1 vccd1 sky130_fd_sc_hd__fill_1
XFILLER_25_449 vssd1 vssd1 vccd1 vccd1 sky130_fd_sc_hd__fill_2
XFILLER_52_235 vssd1 vssd1 vccd1 vccd1 sky130_fd_sc_hd__decap_4
Xclkbuf_leaf_17_clk clkload1/A vssd1 vssd1 vccd1 vccd1 _4819_/CLK sky130_fd_sc_hd__clkbuf_8
XTAP_TAPCELL_ROW_63_753 vssd1 vccd1 sky130_fd_sc_hd__tapvpwrvgnd_1
XFILLER_40_419 vssd1 vssd1 vccd1 vccd1 sky130_fd_sc_hd__fill_1
XANTENNA__4072__C _4100_/C vssd1 vssd1 vccd1 vccd1 sky130_fd_sc_hd__diode_2
XFILLER_20_165 vssd1 vssd1 vccd1 vccd1 sky130_fd_sc_hd__decap_4
X_4777_ _4780_/CLK _4777_/D fanout400/X vssd1 vssd1 vccd1 vccd1 _4777_/Q sky130_fd_sc_hd__dfrtp_1
XANTENNA__3684__S _3741_/S vssd1 vssd1 vccd1 vccd1 sky130_fd_sc_hd__diode_2
XANTENNA_fanout401_A fanout404/X vssd1 vssd1 vccd1 vccd1 sky130_fd_sc_hd__diode_2
X_3728_ _3661_/A _3661_/B _3727_/X vssd1 vssd1 vccd1 vccd1 _3728_/Y sky130_fd_sc_hd__a21oi_1
X_3659_ _3642_/X _3656_/B _3656_/C _3658_/X _3653_/B vssd1 vssd1 vccd1 vccd1 _3661_/B
+ sky130_fd_sc_hd__a311oi_4
XFILLER_87_132 vssd1 vssd1 vccd1 vccd1 sky130_fd_sc_hd__fill_1
XFILLER_75_327 vssd1 vssd1 vccd1 vccd1 sky130_fd_sc_hd__decap_8
XFILLER_75_349 vssd1 vssd1 vccd1 vccd1 sky130_fd_sc_hd__fill_1
XFILLER_28_265 vssd1 vssd1 vccd1 vccd1 sky130_fd_sc_hd__fill_1
XFILLER_83_393 vssd1 vssd1 vccd1 vccd1 sky130_fd_sc_hd__decap_4
XFILLER_16_416 vssd1 vssd1 vccd1 vccd1 sky130_fd_sc_hd__decap_4
XTAP_TAPCELL_ROW_26_422 vssd1 vccd1 sky130_fd_sc_hd__tapvpwrvgnd_1
XFILLER_31_419 vssd1 vssd1 vccd1 vccd1 sky130_fd_sc_hd__decap_4
XFILLER_11_165 vssd1 vssd1 vccd1 vccd1 sky130_fd_sc_hd__decap_3
XFILLER_22_61 vssd1 vssd1 vccd1 vccd1 sky130_fd_sc_hd__fill_1
XFILLER_3_331 vssd1 vssd1 vccd1 vccd1 sky130_fd_sc_hd__decap_4
XFILLER_3_397 vssd1 vssd1 vccd1 vccd1 sky130_fd_sc_hd__fill_1
XFILLER_78_176 vssd1 vssd1 vccd1 vccd1 sky130_fd_sc_hd__fill_1
XFILLER_66_327 vssd1 vssd1 vccd1 vccd1 sky130_fd_sc_hd__decap_8
XTAP_TAPCELL_ROW_77_878 vssd1 vccd1 sky130_fd_sc_hd__tapvpwrvgnd_1
XFILLER_19_254 vssd1 vssd1 vccd1 vccd1 sky130_fd_sc_hd__decap_3
XFILLER_74_382 vssd1 vssd1 vccd1 vccd1 sky130_fd_sc_hd__decap_3
X_2961_ _2873_/A _3862_/B _3005_/B _2960_/B vssd1 vssd1 vccd1 vccd1 _2961_/X sky130_fd_sc_hd__o2bb2a_1
XFILLER_15_460 vssd1 vssd1 vccd1 vccd1 sky130_fd_sc_hd__fill_2
XANTENNA__3423__A1 _3423_/A1 vssd1 vssd1 vccd1 vccd1 sky130_fd_sc_hd__diode_2
XFILLER_15_482 vssd1 vssd1 vccd1 vccd1 sky130_fd_sc_hd__fill_1
X_4700_ clkload9/A _4700_/D fanout387/X vssd1 vssd1 vccd1 vccd1 _4700_/Q sky130_fd_sc_hd__dfrtp_1
XFILLER_8_41 vccd1 vssd1 vccd1 vssd1 sky130_ef_sc_hd__decap_12
X_4631_ _4631_/CLK _4631_/D fanout411/X vssd1 vssd1 vccd1 vccd1 _4631_/Q sky130_fd_sc_hd__dfrtp_1
X_2892_ _2893_/A _2893_/B _2893_/C vssd1 vssd1 vccd1 vccd1 _2895_/C sky130_fd_sc_hd__and3_1
XFILLER_8_85 vssd1 vssd1 vccd1 vccd1 sky130_fd_sc_hd__fill_1
X_4562_ _4562_/CLK _4562_/D _3923_/C vssd1 vssd1 vccd1 vccd1 _4562_/Q sky130_fd_sc_hd__dfrtp_2
X_3513_ _3507_/A _3512_/X _3525_/B1 vssd1 vssd1 vccd1 vccd1 _3513_/X sky130_fd_sc_hd__a21o_1
XFILLER_6_180 vssd1 vssd1 vccd1 vccd1 sky130_fd_sc_hd__fill_2
X_4493_ _4579_/CLK _4493_/D fanout433/X vssd1 vssd1 vccd1 vccd1 hold44/A sky130_fd_sc_hd__dfrtp_1
Xclkbuf_leaf_6_clk clkload1/A vssd1 vssd1 vccd1 vccd1 _4774_/CLK sky130_fd_sc_hd__clkbuf_8
X_3444_ _4602_/Q _3504_/A2 _3477_/B1 _3923_/A vssd1 vssd1 vccd1 vccd1 _3444_/X sky130_fd_sc_hd__o211a_1
X_3375_ _3282_/A _4589_/Q _3284_/D _3278_/X vssd1 vssd1 vccd1 vccd1 _3380_/B sky130_fd_sc_hd__o211ai_4
XTAP_TAPCELL_ROW_68_801 vssd1 vccd1 sky130_fd_sc_hd__tapvpwrvgnd_1
X_2326_ _2341_/A0 _2341_/A1 _4029_/D vssd1 vssd1 vccd1 vccd1 _2326_/X sky130_fd_sc_hd__mux2_1
X_2257_ hold43/X _4565_/Q _2272_/S vssd1 vssd1 vccd1 vccd1 _4436_/D sky130_fd_sc_hd__mux2_1
XANTENNA_fanout184_A _4099_/A0 vssd1 vssd1 vccd1 vccd1 sky130_fd_sc_hd__diode_2
XANTENNA__4364__A _4364_/A vssd1 vssd1 vccd1 vccd1 sky130_fd_sc_hd__diode_2
XFILLER_25_257 vssd1 vssd1 vccd1 vccd1 sky130_fd_sc_hd__fill_2
XFILLER_80_374 vssd1 vssd1 vccd1 vccd1 sky130_fd_sc_hd__decap_6
XFILLER_13_408 vccd1 vssd1 vccd1 vssd1 sky130_ef_sc_hd__decap_12
XFILLER_21_441 vssd1 vssd1 vccd1 vccd1 sky130_fd_sc_hd__decap_4
XFILLER_21_463 vssd1 vssd1 vccd1 vccd1 sky130_fd_sc_hd__decap_8
XANTENNA__4375__C1 _4377_/B1 vssd1 vssd1 vccd1 vccd1 sky130_fd_sc_hd__diode_2
XANTENNA_fanout404_X fanout404/X vssd1 vssd1 vccd1 vccd1 sky130_fd_sc_hd__diode_2
XFILLER_4_139 vssd1 vssd1 vccd1 vccd1 sky130_fd_sc_hd__fill_1
XANTENNA_fanout97_A _3735_/S vssd1 vssd1 vccd1 vccd1 sky130_fd_sc_hd__diode_2
XFILLER_0_389 vssd1 vssd1 vccd1 vccd1 sky130_fd_sc_hd__decap_3
XTAP_TAPCELL_ROW_74_859 vssd1 vccd1 sky130_fd_sc_hd__tapvpwrvgnd_1
XFILLER_31_238 vssd1 vssd1 vccd1 vccd1 sky130_fd_sc_hd__decap_8
XFILLER_3_161 vssd1 vssd1 vccd1 vccd1 sky130_fd_sc_hd__decap_6
XANTENNA__4133__A2 _4173_/A2 vssd1 vssd1 vccd1 vccd1 sky130_fd_sc_hd__diode_2
X_3160_ _4539_/Q input1/X vssd1 vssd1 vccd1 vccd1 _3160_/Y sky130_fd_sc_hd__nand2b_1
X_3091_ _3091_/A _3091_/B vssd1 vssd1 vccd1 vccd1 _3091_/X sky130_fd_sc_hd__or2_1
Xhold1 hold1/A vssd1 vssd1 vccd1 vccd1 hold1/X sky130_fd_sc_hd__dlygate4sd3_1
XFILLER_47_393 vccd1 vssd1 vccd1 vssd1 sky130_ef_sc_hd__decap_12
XPHY_EDGE_ROW_8_Right_8 vssd1 vssd1 vccd1 vccd1 sky130_fd_sc_hd__decap_3
X_3993_ _3976_/D _4001_/B _4001_/C _4123_/S vssd1 vssd1 vccd1 vccd1 _3993_/X sky130_fd_sc_hd__and4b_1
XFILLER_22_227 vssd1 vssd1 vccd1 vccd1 sky130_fd_sc_hd__decap_6
XTAP_TAPCELL_ROW_45_594 vssd1 vccd1 sky130_fd_sc_hd__tapvpwrvgnd_1
X_2944_ _2944_/A _2944_/B vssd1 vssd1 vccd1 vccd1 _2944_/X sky130_fd_sc_hd__xor2_1
X_2875_ _4762_/Q _4777_/Q vssd1 vssd1 vccd1 vccd1 _2876_/B sky130_fd_sc_hd__nor2_1
XANTENNA__4123__S _4123_/S vssd1 vssd1 vccd1 vccd1 sky130_fd_sc_hd__diode_2
X_4614_ _4667_/CLK _4614_/D fanout413/X vssd1 vssd1 vccd1 vccd1 _4614_/Q sky130_fd_sc_hd__dfrtp_1
X_4545_ _4546_/CLK _4545_/D fanout417/X vssd1 vssd1 vccd1 vccd1 _4545_/Q sky130_fd_sc_hd__dfrtp_2
X_4476_ _4553_/CLK _4476_/D fanout419/X vssd1 vssd1 vccd1 vccd1 hold4/A sky130_fd_sc_hd__dfrtp_1
XPHY_EDGE_ROW_39_Right_39 vssd1 vssd1 vccd1 vccd1 sky130_fd_sc_hd__decap_3
X_3427_ _3427_/A _3427_/B vssd1 vssd1 vccd1 vccd1 _3427_/Y sky130_fd_sc_hd__xnor2_1
X_3358_ _3354_/B _3354_/A _3268_/Y vssd1 vssd1 vccd1 vccd1 _3359_/A sky130_fd_sc_hd__o21a_1
X_2309_ hold116/X _3999_/B2 _2307_/Y _2308_/X vssd1 vssd1 vccd1 vccd1 _4459_/D sky130_fd_sc_hd__o22a_1
XFILLER_38_38 vssd1 vssd1 vccd1 vccd1 sky130_fd_sc_hd__fill_1
XFILLER_85_477 vccd1 vssd1 vccd1 vssd1 sky130_ef_sc_hd__decap_12
X_3289_ _3287_/Y _3277_/Y _3253_/Y vssd1 vssd1 vccd1 vccd1 _3289_/Y sky130_fd_sc_hd__o21ai_2
XFILLER_65_190 vccd1 vssd1 vccd1 vssd1 sky130_ef_sc_hd__decap_12
XANTENNA_fanout354_X _2274_/B vssd1 vssd1 vccd1 vccd1 sky130_fd_sc_hd__diode_2
XTAP_TAPCELL_ROW_71_829 vssd1 vccd1 sky130_fd_sc_hd__tapvpwrvgnd_1
XTAP_TAPCELL_ROW_0_186 vssd1 vccd1 sky130_fd_sc_hd__tapvpwrvgnd_1
XFILLER_54_59 vssd1 vssd1 vccd1 vccd1 sky130_fd_sc_hd__fill_2
XPHY_EDGE_ROW_48_Right_48 vssd1 vssd1 vccd1 vccd1 sky130_fd_sc_hd__decap_3
XPHY_EDGE_ROW_57_Right_57 vssd1 vssd1 vccd1 vccd1 sky130_fd_sc_hd__decap_3
XTAP_TAPCELL_ROW_8_264 vssd1 vccd1 sky130_fd_sc_hd__tapvpwrvgnd_1
XFILLER_0_153 vccd1 vssd1 vccd1 vssd1 sky130_ef_sc_hd__decap_12
XTAP_TAPCELL_ROW_87_973 vssd1 vccd1 sky130_fd_sc_hd__tapvpwrvgnd_1
XTAP_TAPCELL_ROW_87_984 vssd1 vccd1 sky130_fd_sc_hd__tapvpwrvgnd_1
XFILLER_28_82 vssd1 vssd1 vccd1 vccd1 sky130_fd_sc_hd__fill_2
XPHY_EDGE_ROW_66_Right_66 vssd1 vssd1 vccd1 vccd1 sky130_fd_sc_hd__decap_3
XFILLER_44_363 vssd1 vssd1 vccd1 vccd1 sky130_fd_sc_hd__fill_1
XANTENNA__4051__A1 _4083_/A1 vssd1 vssd1 vccd1 vccd1 sky130_fd_sc_hd__diode_2
XTAP_TAPCELL_ROW_42_564 vssd1 vccd1 sky130_fd_sc_hd__tapvpwrvgnd_1
XANTENNA__3993__D _4123_/S vssd1 vssd1 vccd1 vccd1 sky130_fd_sc_hd__diode_2
XFILLER_8_253 vccd1 vssd1 vccd1 vssd1 sky130_ef_sc_hd__decap_12
X_2660_ _2659_/Y _4771_/Q _2716_/A vssd1 vssd1 vccd1 vccd1 _2716_/B sky130_fd_sc_hd__nand3b_1
XPHY_EDGE_ROW_75_Right_75 vssd1 vssd1 vccd1 vccd1 sky130_fd_sc_hd__decap_3
X_2591_ _2592_/B _2592_/A vssd1 vssd1 vccd1 vccd1 _2593_/A sky130_fd_sc_hd__and2_1
X_4330_ _4329_/Y _4328_/X _4327_/X hold134/X _4338_/A2 vssd1 vssd1 vccd1 vccd1 _4775_/D
+ sky130_fd_sc_hd__o32a_1
X_4261_ _4281_/A0 _4281_/A1 _4266_/D vssd1 vssd1 vccd1 vccd1 _4261_/X sky130_fd_sc_hd__mux2_1
X_3212_ _4560_/Q _4601_/Q _3211_/X vssd1 vssd1 vccd1 vccd1 _3213_/B sky130_fd_sc_hd__o21a_1
X_4192_ _4324_/A _4212_/A2 _4192_/B1 vssd1 vssd1 vccd1 vccd1 _4192_/Y sky130_fd_sc_hd__o21ai_1
X_3143_ _3865_/A _3143_/B vssd1 vssd1 vccd1 vccd1 _3144_/B sky130_fd_sc_hd__nand2_1
XFILLER_39_146 vccd1 vssd1 vccd1 vssd1 sky130_ef_sc_hd__decap_12
XPHY_EDGE_ROW_84_Right_84 vssd1 vssd1 vccd1 vccd1 sky130_fd_sc_hd__decap_3
X_3074_ _3074_/A _3074_/B _3074_/C vssd1 vssd1 vccd1 vccd1 _3104_/A sky130_fd_sc_hd__or3_1
XFILLER_54_105 vssd1 vssd1 vccd1 vccd1 sky130_fd_sc_hd__fill_2
XANTENNA__4064__D _4064_/D vssd1 vssd1 vccd1 vccd1 sky130_fd_sc_hd__diode_2
XFILLER_50_333 vssd1 vssd1 vccd1 vccd1 sky130_fd_sc_hd__decap_6
X_3976_ _3981_/D _3977_/B _3977_/C _3976_/D vssd1 vssd1 vccd1 vccd1 _3976_/X sky130_fd_sc_hd__and4b_1
XANTENNA__4042__A1 _4702_/Q vssd1 vssd1 vccd1 vccd1 sky130_fd_sc_hd__diode_2
XFILLER_50_355 vssd1 vssd1 vccd1 vccd1 sky130_fd_sc_hd__fill_1
XFILLER_50_377 vssd1 vssd1 vccd1 vccd1 sky130_fd_sc_hd__fill_1
X_2927_ _2927_/A _2927_/B vssd1 vssd1 vccd1 vccd1 _2928_/B sky130_fd_sc_hd__nand2_1
XANTENNA_fanout314_A _4797_/Q vssd1 vssd1 vccd1 vccd1 sky130_fd_sc_hd__diode_2
XANTENNA__4080__C _4104_/C vssd1 vssd1 vccd1 vccd1 sky130_fd_sc_hd__diode_2
X_2858_ _2858_/A _2858_/B vssd1 vssd1 vccd1 vccd1 _2858_/Y sky130_fd_sc_hd__nor2_1
XANTENNA__4345__A2 _4328_/C vssd1 vssd1 vccd1 vccd1 sky130_fd_sc_hd__diode_2
X_2789_ _2743_/C _2745_/A _2785_/X _2786_/X vssd1 vssd1 vccd1 vccd1 _2790_/B sky130_fd_sc_hd__a211o_1
Xhold220 _4743_/Q vssd1 vssd1 vccd1 vccd1 hold220/X sky130_fd_sc_hd__dlygate4sd3_1
X_4528_ _4640_/CLK _4528_/D fanout425/X vssd1 vssd1 vccd1 vccd1 _4528_/Q sky130_fd_sc_hd__dfrtp_2
X_4459_ _4808_/CLK _4459_/D fanout377/X vssd1 vssd1 vccd1 vccd1 _4459_/Q sky130_fd_sc_hd__dfrtp_1
XANTENNA__4239__D _4239_/D vssd1 vssd1 vccd1 vccd1 sky130_fd_sc_hd__diode_2
XTAP_TAPCELL_ROW_5_234 vssd1 vccd1 sky130_fd_sc_hd__tapvpwrvgnd_1
XFILLER_85_285 vssd1 vssd1 vccd1 vccd1 sky130_fd_sc_hd__fill_1
XFILLER_58_477 vssd1 vssd1 vccd1 vccd1 sky130_fd_sc_hd__decap_4
XTAP_TAPCELL_ROW_84_943 vssd1 vccd1 sky130_fd_sc_hd__tapvpwrvgnd_1
XFILLER_73_447 vssd1 vssd1 vccd1 vccd1 sky130_fd_sc_hd__fill_1
XTAP_TAPCELL_ROW_56_689 vssd1 vccd1 sky130_fd_sc_hd__tapvpwrvgnd_1
XANTENNA__2292__B1 _3928_/S vssd1 vssd1 vccd1 vccd1 sky130_fd_sc_hd__diode_2
XFILLER_14_51 vssd1 vssd1 vccd1 vccd1 sky130_fd_sc_hd__decap_8
XFILLER_49_455 vssd1 vssd1 vccd1 vccd1 sky130_fd_sc_hd__fill_1
XFILLER_64_425 vssd1 vssd1 vccd1 vccd1 sky130_fd_sc_hd__fill_1
XTAP_TAPCELL_ROW_47_612 vssd1 vccd1 sky130_fd_sc_hd__tapvpwrvgnd_1
XFILLER_64_469 vssd1 vssd1 vccd1 vccd1 sky130_fd_sc_hd__decap_6
XFILLER_36_138 vssd1 vssd1 vccd1 vccd1 sky130_fd_sc_hd__fill_2
XTAP_TAPCELL_ROW_19_358 vssd1 vccd1 sky130_fd_sc_hd__tapvpwrvgnd_1
X_3830_ hold190/X _3830_/A2 _3829_/Y vssd1 vssd1 vccd1 vccd1 _4633_/D sky130_fd_sc_hd__a21o_1
X_3761_ _3743_/D _3742_/Y _4533_/Q _4642_/Q vssd1 vssd1 vccd1 vccd1 _3761_/X sky130_fd_sc_hd__a2bb2o_1
XFILLER_32_388 vssd1 vssd1 vccd1 vccd1 sky130_fd_sc_hd__fill_1
X_2712_ _2724_/A _2724_/B _2724_/C vssd1 vssd1 vccd1 vccd1 _2725_/A sky130_fd_sc_hd__a21o_1
X_3692_ _4527_/Q _4636_/Q vssd1 vssd1 vccd1 vccd1 _3701_/A sky130_fd_sc_hd__nand2_1
X_2643_ _2599_/B _2599_/A _2599_/C vssd1 vssd1 vccd1 vccd1 _2648_/A sky130_fd_sc_hd__o21bai_1
XTAP_TAPCELL_ROW_10_280 vssd1 vccd1 sky130_fd_sc_hd__tapvpwrvgnd_1
X_2574_ _4693_/Q _4680_/Q vssd1 vssd1 vccd1 vccd1 _2617_/C sky130_fd_sc_hd__nand2_1
X_4313_ _4339_/A0 _4343_/A1 _4313_/S vssd1 vssd1 vccd1 vccd1 _4313_/X sky130_fd_sc_hd__mux2_1
XFILLER_87_517 vssd1 vssd1 vccd1 vccd1 sky130_fd_sc_hd__fill_2
X_4244_ _4753_/Q _4361_/B1 _4243_/Y _4242_/X vssd1 vssd1 vccd1 vccd1 _4753_/D sky130_fd_sc_hd__a22o_1
X_4175_ _4223_/D _4175_/B _4175_/C _4238_/S vssd1 vssd1 vccd1 vccd1 _4175_/Y sky130_fd_sc_hd__nand4b_1
XTAP_TAPCELL_ROW_2_204 vssd1 vccd1 sky130_fd_sc_hd__tapvpwrvgnd_1
X_3126_ _3119_/Y _3126_/B _3126_/C vssd1 vssd1 vccd1 vccd1 _3126_/X sky130_fd_sc_hd__and3b_1
XANTENNA__2428__Y _2428_/Y vssd1 vssd1 vccd1 vccd1 sky130_fd_sc_hd__diode_2
XFILLER_55_436 vssd1 vssd1 vccd1 vccd1 sky130_fd_sc_hd__fill_1
XANTENNA_fanout264_A _4815_/Q vssd1 vssd1 vccd1 vccd1 sky130_fd_sc_hd__diode_2
X_3057_ _3074_/C _3061_/B _3018_/B _3026_/A _3026_/B vssd1 vssd1 vccd1 vccd1 _3067_/A
+ sky130_fd_sc_hd__o32a_1
XANTENNA__4263__A1 _4323_/S vssd1 vssd1 vccd1 vccd1 sky130_fd_sc_hd__diode_2
XANTENNA__3471__C1 _3543_/A vssd1 vssd1 vccd1 vccd1 sky130_fd_sc_hd__diode_2
XFILLER_42_119 vssd1 vssd1 vccd1 vccd1 sky130_fd_sc_hd__fill_1
XANTENNA__4372__A _4372_/A vssd1 vssd1 vccd1 vccd1 sky130_fd_sc_hd__diode_2
XFILLER_23_355 vssd1 vssd1 vccd1 vccd1 sky130_fd_sc_hd__decap_4
X_3959_ _4087_/S _3974_/A1 _4021_/D _3899_/Y vssd1 vssd1 vccd1 vccd1 _3959_/X sky130_fd_sc_hd__o2bb2a_1
XANTENNA_fanout317_X _4215_/C vssd1 vssd1 vccd1 vccd1 sky130_fd_sc_hd__diode_2
XFILLER_76_68 vccd1 vssd1 vccd1 vssd1 sky130_ef_sc_hd__decap_12
XFILLER_73_222 vssd1 vssd1 vccd1 vccd1 sky130_fd_sc_hd__fill_2
XFILLER_18_127 vssd1 vssd1 vccd1 vccd1 sky130_fd_sc_hd__fill_2
XFILLER_46_436 vssd1 vssd1 vccd1 vccd1 sky130_fd_sc_hd__fill_1
XFILLER_46_469 vssd1 vssd1 vccd1 vccd1 sky130_fd_sc_hd__decap_6
XANTENNA__4006__A1 _4005_/D vssd1 vssd1 vccd1 vccd1 sky130_fd_sc_hd__diode_2
XFILLER_41_196 vssd1 vssd1 vccd1 vccd1 sky130_fd_sc_hd__decap_3
XANTENNA__4427__RESET_B fanout423/X vssd1 vssd1 vccd1 vccd1 sky130_fd_sc_hd__diode_2
XANTENNA__4190__A0 _4214_/A0 vssd1 vssd1 vccd1 vccd1 sky130_fd_sc_hd__diode_2
X_2290_ _3875_/A0 _2310_/A1 _4123_/S vssd1 vssd1 vccd1 vccd1 _2290_/X sky130_fd_sc_hd__mux2_1
XFILLER_1_281 vssd1 vssd1 vccd1 vccd1 sky130_fd_sc_hd__fill_1
XFILLER_2_43 vssd1 vssd1 vccd1 vccd1 sky130_fd_sc_hd__decap_6
XFILLER_49_241 vccd1 vssd1 vccd1 vssd1 sky130_ef_sc_hd__decap_12
XANTENNA__4245__A_N _4313_/S vssd1 vssd1 vccd1 vccd1 sky130_fd_sc_hd__diode_2
XFILLER_52_417 vssd1 vssd1 vccd1 vccd1 sky130_fd_sc_hd__fill_1
XFILLER_64_299 vssd1 vssd1 vccd1 vccd1 sky130_fd_sc_hd__fill_2
XFILLER_52_439 vssd1 vssd1 vccd1 vccd1 sky130_fd_sc_hd__fill_1
X_3813_ _2532_/X _2534_/Y _2535_/Y vssd1 vssd1 vccd1 vccd1 _3813_/Y sky130_fd_sc_hd__a21oi_1
X_4793_ _4794_/CLK _4793_/D fanout375/X vssd1 vssd1 vccd1 vccd1 _4793_/Q sky130_fd_sc_hd__dfrtp_1
X_3744_ _3743_/D _3742_/Y _3759_/D _3734_/B vssd1 vssd1 vccd1 vccd1 _3748_/A sky130_fd_sc_hd__o22ai_2
X_3675_ _4523_/Q _4632_/Q _4524_/Q _4633_/Q vssd1 vssd1 vccd1 vccd1 _3675_/X sky130_fd_sc_hd__a22o_1
X_2626_ _2621_/B _2621_/C _2621_/A _2623_/B _2623_/A vssd1 vssd1 vccd1 vccd1 _2641_/A
+ sky130_fd_sc_hd__a32oi_4
XANTENNA__4131__S _4203_/C vssd1 vssd1 vccd1 vccd1 sky130_fd_sc_hd__diode_2
X_2557_ _2557_/A _4706_/Q _4721_/Q vssd1 vssd1 vccd1 vccd1 _2590_/A sky130_fd_sc_hd__and3_1
X_2488_ _2502_/A _2488_/B vssd1 vssd1 vccd1 vccd1 _3809_/A sky130_fd_sc_hd__nand2_1
X_4227_ _4178_/D _4239_/B _4227_/C _4231_/D vssd1 vssd1 vccd1 vccd1 _4227_/X sky130_fd_sc_hd__and4b_1
XANTENNA_fanout381_A fanout382/X vssd1 vssd1 vccd1 vccd1 sky130_fd_sc_hd__diode_2
XTAP_TAPCELL_ROW_58_707 vssd1 vccd1 sky130_fd_sc_hd__tapvpwrvgnd_1
X_4158_ _4155_/X _4156_/X _4157_/Y _4280_/B2 hold78/X vssd1 vssd1 vccd1 vccd1 _4731_/D
+ sky130_fd_sc_hd__o32a_1
X_3109_ _3085_/C _3087_/C _3107_/X _3108_/Y vssd1 vssd1 vccd1 vccd1 _3112_/A sky130_fd_sc_hd__a211oi_2
XANTENNA_fanout267_X _4199_/D vssd1 vssd1 vccd1 vccd1 sky130_fd_sc_hd__diode_2
X_4089_ _4223_/C _4105_/A2 _4208_/B1 vssd1 vssd1 vccd1 vccd1 _4089_/Y sky130_fd_sc_hd__o21ai_1
XFILLER_55_277 vssd1 vssd1 vccd1 vccd1 sky130_fd_sc_hd__decap_3
XTAP_TAPCELL_ROW_66_784 vssd1 vccd1 sky130_fd_sc_hd__tapvpwrvgnd_1
XFILLER_43_428 vssd1 vssd1 vccd1 vccd1 sky130_fd_sc_hd__fill_1
XANTENNA__3444__C1 _3923_/A vssd1 vssd1 vccd1 vccd1 sky130_fd_sc_hd__diode_2
XTAP_TAPCELL_ROW_13_309 vssd1 vccd1 sky130_fd_sc_hd__tapvpwrvgnd_1
XFILLER_51_461 vssd1 vssd1 vccd1 vccd1 sky130_fd_sc_hd__fill_2
XPHY_EDGE_ROW_12_Left_100 vssd1 vssd1 vccd1 vccd1 sky130_fd_sc_hd__decap_3
XTAP_TAPCELL_ROW_21_375 vssd1 vccd1 sky130_fd_sc_hd__tapvpwrvgnd_1
XFILLER_11_30 vccd1 vssd1 vccd1 vssd1 sky130_ef_sc_hd__decap_12
Xfanout371 _3784_/B1 vssd1 vssd1 vccd1 vccd1 _3308_/B sky130_fd_sc_hd__buf_2
Xfanout382 fanout405/X vssd1 vssd1 vccd1 vccd1 fanout382/X sky130_fd_sc_hd__buf_2
Xfanout360 _3794_/A0 vssd1 vssd1 vccd1 vccd1 _3504_/A2 sky130_fd_sc_hd__clkbuf_4
Xfanout393 fanout398/X vssd1 vssd1 vccd1 vccd1 fanout393/X sky130_fd_sc_hd__dlymetal6s2s_1
XFILLER_46_211 vssd1 vssd1 vccd1 vccd1 sky130_fd_sc_hd__decap_6
XTAP_TAPCELL_ROW_29_453 vssd1 vccd1 sky130_fd_sc_hd__tapvpwrvgnd_1
XFILLER_46_244 vssd1 vssd1 vccd1 vccd1 sky130_fd_sc_hd__decap_3
XFILLER_61_203 vssd1 vssd1 vccd1 vccd1 sky130_fd_sc_hd__fill_1
XFILLER_14_163 vssd1 vssd1 vccd1 vccd1 sky130_fd_sc_hd__decap_4
XFILLER_42_450 vssd1 vssd1 vccd1 vccd1 sky130_fd_sc_hd__fill_2
XANTENNA__3450__A2 _3534_/A2 vssd1 vssd1 vccd1 vccd1 sky130_fd_sc_hd__diode_2
Xinput13 s_axis_tdata[19] vssd1 vssd1 vccd1 vccd1 input13/X sky130_fd_sc_hd__clkbuf_1
Xinput24 s_axis_tdata[29] vssd1 vssd1 vccd1 vccd1 input24/X sky130_fd_sc_hd__clkbuf_1
Xinput35 s_axis_tuser vssd1 vssd1 vccd1 vccd1 input35/X sky130_fd_sc_hd__clkbuf_1
XANTENNA__4163__A0 _4171_/A0 vssd1 vssd1 vccd1 vccd1 sky130_fd_sc_hd__diode_2
X_3460_ _3460_/A1 _3458_/Y _3459_/X _3460_/B1 vssd1 vssd1 vccd1 vccd1 _3460_/Y sky130_fd_sc_hd__a31oi_1
X_2411_ _4573_/Q hold63/A _2421_/S vssd1 vssd1 vccd1 vccd1 _2411_/X sky130_fd_sc_hd__mux2_1
X_3391_ _4551_/Q _3396_/A2 _3389_/X _3390_/X vssd1 vssd1 vccd1 vccd1 _4551_/D sky130_fd_sc_hd__a22o_1
X_2342_ hold150/X _4038_/B1 _2339_/X _2341_/X vssd1 vssd1 vccd1 vccd1 _4467_/D sky130_fd_sc_hd__o22a_1
XFILLER_69_358 vssd1 vssd1 vccd1 vccd1 sky130_fd_sc_hd__decap_4
XFILLER_84_306 vssd1 vssd1 vccd1 vccd1 sky130_fd_sc_hd__fill_2
X_4012_ _4036_/A0 _4036_/A1 _4017_/D vssd1 vssd1 vccd1 vccd1 _4012_/X sky130_fd_sc_hd__mux2_1
X_2273_ _3613_/C _2274_/B vssd1 vssd1 vccd1 vccd1 _2273_/X sky130_fd_sc_hd__and2_2
XFILLER_25_406 vssd1 vssd1 vccd1 vccd1 sky130_fd_sc_hd__fill_1
XFILLER_37_277 vssd1 vssd1 vccd1 vccd1 sky130_fd_sc_hd__fill_1
XTAP_TAPCELL_ROW_63_754 vssd1 vccd1 sky130_fd_sc_hd__tapvpwrvgnd_1
XANTENNA__4072__D _4274_/D vssd1 vssd1 vccd1 vccd1 sky130_fd_sc_hd__diode_2
X_4776_ _4776_/CLK _4776_/D fanout400/X vssd1 vssd1 vccd1 vccd1 _4776_/Q sky130_fd_sc_hd__dfrtp_1
XANTENNA_clkbuf_leaf_12_clk_A clkload1/A vssd1 vssd1 vccd1 vccd1 sky130_fd_sc_hd__diode_2
X_3727_ _3727_/A _3727_/B _3727_/C vssd1 vssd1 vccd1 vccd1 _3727_/X sky130_fd_sc_hd__or3_1
X_3658_ _4522_/Q _4631_/Q _4521_/Q _4630_/Q vssd1 vssd1 vccd1 vccd1 _3658_/X sky130_fd_sc_hd__o211a_1
X_3589_ _3578_/A _3578_/B _3587_/A _3587_/B _3582_/Y vssd1 vssd1 vccd1 vccd1 _3589_/X
+ sky130_fd_sc_hd__o221a_1
X_2609_ _2646_/B _2609_/B vssd1 vssd1 vccd1 vccd1 _2610_/B sky130_fd_sc_hd__nor2_1
XANTENNA_clkbuf_leaf_27_clk_A clkbuf_2_3__f_clk/X vssd1 vssd1 vccd1 vccd1 sky130_fd_sc_hd__diode_2
XFILLER_0_505 vccd1 vssd1 vccd1 vssd1 sky130_ef_sc_hd__decap_12
XFILLER_83_350 vccd1 vssd1 vccd1 vssd1 sky130_ef_sc_hd__decap_12
XFILLER_71_501 vssd1 vssd1 vccd1 vccd1 sky130_fd_sc_hd__fill_1
Xclkbuf_2_2__f_clk clkbuf_0_clk/X vssd1 vssd1 vccd1 vccd1 clkload2/A sky130_fd_sc_hd__clkbuf_16
XFILLER_43_225 vssd1 vssd1 vccd1 vccd1 sky130_fd_sc_hd__fill_2
XTAP_TAPCELL_ROW_26_423 vssd1 vccd1 sky130_fd_sc_hd__tapvpwrvgnd_1
XANTENNA__4036__S _4036_/S vssd1 vssd1 vccd1 vccd1 sky130_fd_sc_hd__diode_2
XFILLER_31_409 vssd1 vssd1 vccd1 vccd1 sky130_fd_sc_hd__fill_1
XANTENNA__3875__S _3928_/S vssd1 vssd1 vccd1 vccd1 sky130_fd_sc_hd__diode_2
XFILLER_3_310 vssd1 vssd1 vccd1 vccd1 sky130_fd_sc_hd__fill_1
XANTENNA__3904__A _4001_/B vssd1 vssd1 vccd1 vccd1 sky130_fd_sc_hd__diode_2
XFILLER_78_122 vssd1 vssd1 vccd1 vccd1 sky130_fd_sc_hd__fill_1
XFILLER_66_317 vssd1 vssd1 vccd1 vccd1 sky130_fd_sc_hd__decap_6
Xfanout190 _3004_/B1 vssd1 vssd1 vccd1 vccd1 _3150_/A sky130_fd_sc_hd__buf_2
XFILLER_19_222 vssd1 vssd1 vccd1 vccd1 sky130_fd_sc_hd__fill_2
XTAP_TAPCELL_ROW_77_879 vssd1 vccd1 sky130_fd_sc_hd__tapvpwrvgnd_1
XFILLER_74_361 vssd1 vssd1 vccd1 vccd1 sky130_fd_sc_hd__decap_3
X_2960_ _3005_/B _2960_/B _3074_/C vssd1 vssd1 vccd1 vccd1 _2960_/Y sky130_fd_sc_hd__nor3_1
X_2891_ _2893_/B _2893_/C _2893_/A vssd1 vssd1 vccd1 vccd1 _2895_/B sky130_fd_sc_hd__a21oi_1
X_4630_ _4631_/CLK _4630_/D fanout411/X vssd1 vssd1 vccd1 vccd1 _4630_/Q sky130_fd_sc_hd__dfrtp_1
XFILLER_8_53 vssd1 vssd1 vccd1 vccd1 sky130_fd_sc_hd__decap_4
XANTENNA__4384__A0 _4063_/S vssd1 vssd1 vccd1 vccd1 sky130_fd_sc_hd__diode_2
XFILLER_30_497 vssd1 vssd1 vccd1 vccd1 sky130_fd_sc_hd__fill_2
X_4561_ _4562_/CLK _4561_/D _3923_/C vssd1 vssd1 vccd1 vccd1 _4561_/Q sky130_fd_sc_hd__dfrtp_1
X_3512_ _3510_/Y _3512_/B vssd1 vssd1 vccd1 vccd1 _3512_/X sky130_fd_sc_hd__and2b_1
X_4492_ _4579_/CLK _4492_/D fanout433/X vssd1 vssd1 vccd1 vccd1 hold70/A sky130_fd_sc_hd__dfrtp_1
X_3443_ _3460_/A1 _3442_/X _3460_/B1 vssd1 vssd1 vccd1 vccd1 _3443_/X sky130_fd_sc_hd__a21o_1
XFILLER_69_111 vssd1 vssd1 vccd1 vccd1 sky130_fd_sc_hd__fill_1
X_3374_ hold87/X _3396_/A2 _3372_/X _3373_/X vssd1 vssd1 vccd1 vccd1 _4548_/D sky130_fd_sc_hd__a22o_1
XFILLER_69_177 vssd1 vssd1 vccd1 vccd1 sky130_fd_sc_hd__fill_2
XTAP_TAPCELL_ROW_68_802 vssd1 vccd1 sky130_fd_sc_hd__tapvpwrvgnd_1
X_2325_ hold112/X _4015_/B2 _2323_/Y _2324_/X vssd1 vssd1 vccd1 vccd1 _4463_/D sky130_fd_sc_hd__o22a_1
X_2256_ hold46/X _4564_/Q _2272_/S vssd1 vssd1 vccd1 vccd1 _4435_/D sky130_fd_sc_hd__mux2_1
XANTENNA_fanout344_A _4789_/Q vssd1 vssd1 vccd1 vccd1 sky130_fd_sc_hd__diode_2
XFILLER_40_239 vssd1 vssd1 vccd1 vccd1 sky130_fd_sc_hd__fill_1
XANTENNA__4375__B1 _4377_/C1 vssd1 vssd1 vccd1 vccd1 sky130_fd_sc_hd__diode_2
XTAP_TAPCELL_ROW_31_470 vssd1 vccd1 sky130_fd_sc_hd__tapvpwrvgnd_1
X_4759_ _4776_/CLK _4759_/D fanout399/X vssd1 vssd1 vccd1 vccd1 _4759_/Q sky130_fd_sc_hd__dfrtp_2
XANTENNA__4127__A0 _4167_/A0 vssd1 vssd1 vccd1 vccd1 sky130_fd_sc_hd__diode_2
XFILLER_0_335 vssd1 vssd1 vccd1 vccd1 sky130_fd_sc_hd__fill_1
XANTENNA__4258__C _4258_/C vssd1 vssd1 vccd1 vccd1 sky130_fd_sc_hd__diode_2
XFILLER_56_361 vssd1 vssd1 vccd1 vccd1 sky130_fd_sc_hd__decap_3
XFILLER_56_372 vssd1 vssd1 vccd1 vccd1 sky130_fd_sc_hd__decap_8
XFILLER_83_191 vssd1 vssd1 vccd1 vccd1 sky130_fd_sc_hd__fill_1
XFILLER_16_225 vssd1 vssd1 vccd1 vccd1 sky130_fd_sc_hd__fill_2
XPHY_EDGE_ROW_9_Left_97 vssd1 vssd1 vccd1 vccd1 sky130_fd_sc_hd__decap_3
XFILLER_12_475 vssd1 vssd1 vccd1 vccd1 sky130_fd_sc_hd__fill_1
XFILLER_79_497 vssd1 vssd1 vccd1 vccd1 sky130_fd_sc_hd__decap_4
X_3090_ _3089_/B _3089_/C _3089_/A vssd1 vssd1 vccd1 vccd1 _3091_/B sky130_fd_sc_hd__a21oi_1
Xhold2 hold2/A vssd1 vssd1 vccd1 vccd1 hold2/X sky130_fd_sc_hd__dlygate4sd3_1
XFILLER_81_128 vccd1 vssd1 vccd1 vssd1 sky130_ef_sc_hd__decap_12
XFILLER_81_106 vssd1 vssd1 vccd1 vccd1 sky130_fd_sc_hd__decap_6
XTAP_TAPCELL_ROW_37_518 vssd1 vccd1 sky130_fd_sc_hd__tapvpwrvgnd_1
X_3992_ _4020_/A0 _4020_/A1 _4064_/D vssd1 vssd1 vccd1 vccd1 _3992_/X sky130_fd_sc_hd__mux2_1
XTAP_TAPCELL_ROW_45_595 vssd1 vccd1 sky130_fd_sc_hd__tapvpwrvgnd_1
X_2943_ _2944_/B _2944_/A vssd1 vssd1 vccd1 vccd1 _2943_/X sky130_fd_sc_hd__and2b_1
XANTENNA__4404__S _4408_/S vssd1 vssd1 vccd1 vccd1 sky130_fd_sc_hd__diode_2
X_2874_ _4762_/Q _4777_/Q vssd1 vssd1 vccd1 vccd1 _2922_/B sky130_fd_sc_hd__and2_1
XANTENNA__4357__B1 _4361_/B1 vssd1 vssd1 vccd1 vccd1 sky130_fd_sc_hd__diode_2
X_4613_ _4613_/CLK _4613_/D fanout429/X vssd1 vssd1 vccd1 vccd1 _4613_/Q sky130_fd_sc_hd__dfrtp_1
X_4544_ _4546_/CLK _4544_/D fanout418/X vssd1 vssd1 vccd1 vccd1 _4544_/Q sky130_fd_sc_hd__dfrtp_2
X_4475_ _4546_/CLK _4475_/D fanout418/X vssd1 vssd1 vccd1 vccd1 hold76/A sky130_fd_sc_hd__dfrtp_1
X_3426_ _4557_/Q _4598_/Q _3289_/Y _3293_/Y vssd1 vssd1 vccd1 vccd1 _3427_/B sky130_fd_sc_hd__a22oi_1
X_3357_ _4545_/Q _3425_/A2 _3355_/X _3356_/X vssd1 vssd1 vccd1 vccd1 _4545_/D sky130_fd_sc_hd__a22o_1
X_2308_ _4005_/D _2295_/C _2295_/B _3886_/S _2306_/X vssd1 vssd1 vccd1 vccd1 _2308_/X
+ sky130_fd_sc_hd__a311o_1
X_3288_ _3370_/B _3275_/Y _3286_/Y vssd1 vssd1 vccd1 vccd1 _3288_/Y sky130_fd_sc_hd__a21boi_2
XFILLER_85_489 vccd1 vssd1 vccd1 vssd1 sky130_ef_sc_hd__decap_12
X_2239_ hold35/X _4547_/Q _2242_/S vssd1 vssd1 vccd1 vccd1 _4418_/D sky130_fd_sc_hd__mux2_1
XFILLER_38_372 vssd1 vssd1 vccd1 vccd1 sky130_fd_sc_hd__fill_1
XFILLER_72_139 vssd1 vssd1 vccd1 vccd1 sky130_fd_sc_hd__fill_1
XANTENNA__2607__B _4754_/Q vssd1 vssd1 vccd1 vccd1 sky130_fd_sc_hd__diode_2
XFILLER_54_27 vssd1 vssd1 vccd1 vccd1 sky130_fd_sc_hd__fill_1
XTAP_TAPCELL_ROW_0_176 vssd1 vccd1 sky130_fd_sc_hd__tapvpwrvgnd_1
XTAP_TAPCELL_ROW_0_187 vssd1 vccd1 sky130_fd_sc_hd__tapvpwrvgnd_1
XANTENNA_fanout347_X _4313_/S vssd1 vssd1 vccd1 vccd1 sky130_fd_sc_hd__diode_2
XFILLER_54_49 vssd1 vssd1 vccd1 vccd1 sky130_fd_sc_hd__decap_6
XANTENNA__3399__A1 _3423_/A1 vssd1 vssd1 vccd1 vccd1 sky130_fd_sc_hd__diode_2
XANTENNA__3719__A _3741_/S vssd1 vssd1 vccd1 vccd1 sky130_fd_sc_hd__diode_2
XFILLER_70_37 vssd1 vssd1 vccd1 vccd1 sky130_fd_sc_hd__fill_1
XANTENNA__4314__S _4314_/S vssd1 vssd1 vccd1 vccd1 sky130_fd_sc_hd__diode_2
XFILLER_79_57 vccd1 vssd1 vccd1 vssd1 sky130_ef_sc_hd__decap_12
XTAP_TAPCELL_ROW_8_265 vssd1 vccd1 sky130_fd_sc_hd__tapvpwrvgnd_1
XFILLER_0_165 vssd1 vssd1 vccd1 vccd1 sky130_fd_sc_hd__fill_1
XFILLER_48_103 vssd1 vssd1 vccd1 vccd1 sky130_fd_sc_hd__decap_3
XTAP_TAPCELL_ROW_87_974 vssd1 vccd1 sky130_fd_sc_hd__tapvpwrvgnd_1
XANTENNA_input22_A s_axis_tdata[27] vssd1 vssd1 vccd1 vccd1 sky130_fd_sc_hd__diode_2
XFILLER_36_309 vccd1 vssd1 vccd1 vssd1 sky130_ef_sc_hd__decap_12
XTAP_TAPCELL_ROW_87_985 vssd1 vccd1 sky130_fd_sc_hd__tapvpwrvgnd_1
XFILLER_28_61 vssd1 vssd1 vccd1 vccd1 sky130_fd_sc_hd__decap_4
XFILLER_81_8 vccd1 vssd1 vccd1 vssd1 sky130_ef_sc_hd__decap_12
XTAP_TAPCELL_ROW_42_565 vssd1 vccd1 sky130_fd_sc_hd__tapvpwrvgnd_1
XFILLER_67_6 vssd1 vssd1 vccd1 vccd1 sky130_fd_sc_hd__fill_1
XFILLER_8_265 vssd1 vssd1 vccd1 vccd1 sky130_fd_sc_hd__decap_4
X_2590_ _2590_/A _2590_/B vssd1 vssd1 vccd1 vccd1 _2592_/B sky130_fd_sc_hd__xor2_1
X_4260_ _4259_/Y _4258_/X _4257_/X hold185/X _4334_/A2 vssd1 vssd1 vccd1 vccd1 _4757_/D
+ sky130_fd_sc_hd__o32a_1
X_4191_ _4258_/C _4211_/B _4199_/D _4324_/A vssd1 vssd1 vccd1 vccd1 _4191_/X sky130_fd_sc_hd__and4b_1
X_3211_ _4560_/Q _4601_/Q _4600_/Q _4559_/Q vssd1 vssd1 vccd1 vccd1 _3211_/X sky130_fd_sc_hd__a22o_1
X_3142_ _4787_/Q _3142_/B vssd1 vssd1 vccd1 vccd1 _3143_/B sky130_fd_sc_hd__or2_1
XFILLER_67_434 vssd1 vssd1 vccd1 vccd1 sky130_fd_sc_hd__decap_6
XFILLER_39_158 vssd1 vssd1 vccd1 vccd1 sky130_fd_sc_hd__decap_8
X_3073_ _4769_/Q _4784_/Q vssd1 vssd1 vccd1 vccd1 _3074_/B sky130_fd_sc_hd__nor2_1
XFILLER_27_309 vccd1 vssd1 vccd1 vssd1 sky130_ef_sc_hd__decap_12
XFILLER_39_169 vccd1 vssd1 vccd1 vssd1 sky130_ef_sc_hd__decap_12
XANTENNA__2427__B _4666_/Q vssd1 vssd1 vccd1 vccd1 sky130_fd_sc_hd__diode_2
XFILLER_35_331 vssd1 vssd1 vccd1 vccd1 sky130_fd_sc_hd__decap_4
XFILLER_62_183 vssd1 vssd1 vccd1 vccd1 sky130_fd_sc_hd__fill_1
XFILLER_62_161 vssd1 vssd1 vccd1 vccd1 sky130_fd_sc_hd__fill_1
XPHY_EDGE_ROW_59_Left_147 vssd1 vssd1 vccd1 vccd1 sky130_fd_sc_hd__decap_3
XANTENNA__4042__A2 _3975_/S vssd1 vssd1 vccd1 vccd1 sky130_fd_sc_hd__diode_2
X_3975_ _3974_/X _2770_/A _3975_/S vssd1 vssd1 vccd1 vccd1 _4685_/D sky130_fd_sc_hd__mux2_1
X_2926_ _2923_/Y _2924_/X _2893_/C _2893_/Y vssd1 vssd1 vccd1 vccd1 _2927_/B sky130_fd_sc_hd__o211ai_1
X_2857_ _2857_/A _2857_/B _2857_/C vssd1 vssd1 vccd1 vccd1 _2858_/B sky130_fd_sc_hd__and3_1
XANTENNA__4080__D _4215_/C vssd1 vssd1 vccd1 vccd1 sky130_fd_sc_hd__diode_2
XANTENNA__4345__A3 _4328_/B vssd1 vssd1 vccd1 vccd1 sky130_fd_sc_hd__diode_2
Xhold210 _4607_/Q vssd1 vssd1 vccd1 vccd1 hold210/X sky130_fd_sc_hd__dlygate4sd3_1
X_2788_ _2743_/C _2745_/A _2785_/X _2786_/X vssd1 vssd1 vccd1 vccd1 _2788_/Y sky130_fd_sc_hd__a211oi_1
XANTENNA_fanout307_A _4799_/Q vssd1 vssd1 vccd1 vccd1 sky130_fd_sc_hd__diode_2
XPHY_EDGE_ROW_68_Left_156 vssd1 vssd1 vccd1 vccd1 sky130_fd_sc_hd__decap_3
X_4527_ _4640_/CLK _4527_/D fanout425/X vssd1 vssd1 vccd1 vccd1 _4527_/Q sky130_fd_sc_hd__dfrtp_1
Xhold221 _4566_/Q vssd1 vssd1 vccd1 vccd1 hold221/X sky130_fd_sc_hd__dlygate4sd3_1
X_4458_ _4686_/CLK _4458_/D fanout385/X vssd1 vssd1 vccd1 vccd1 _4458_/Q sky130_fd_sc_hd__dfrtp_1
X_3409_ _4554_/Q _3425_/A2 _3407_/X _3408_/X vssd1 vssd1 vccd1 vccd1 _4554_/D sky130_fd_sc_hd__a22o_1
X_4389_ _4223_/C input4/X _4408_/S vssd1 vssd1 vccd1 vccd1 _4798_/D sky130_fd_sc_hd__mux2_1
XTAP_TAPCELL_ROW_5_235 vssd1 vccd1 sky130_fd_sc_hd__tapvpwrvgnd_1
XANTENNA_fanout297_X _4036_/S vssd1 vssd1 vccd1 vccd1 sky130_fd_sc_hd__diode_2
XFILLER_85_275 vssd1 vssd1 vccd1 vccd1 sky130_fd_sc_hd__decap_4
XFILLER_18_309 vccd1 vssd1 vccd1 vssd1 sky130_ef_sc_hd__decap_12
XTAP_TAPCELL_ROW_84_944 vssd1 vccd1 sky130_fd_sc_hd__tapvpwrvgnd_1
XPHY_EDGE_ROW_77_Left_165 vssd1 vssd1 vccd1 vccd1 sky130_fd_sc_hd__decap_3
XANTENNA__2292__A1 _4119_/S vssd1 vssd1 vccd1 vccd1 sky130_fd_sc_hd__diode_2
XFILLER_26_386 vssd1 vssd1 vccd1 vccd1 sky130_fd_sc_hd__fill_1
XFILLER_41_334 vssd1 vssd1 vccd1 vccd1 sky130_fd_sc_hd__fill_2
XFILLER_14_85 vssd1 vssd1 vccd1 vccd1 sky130_fd_sc_hd__fill_2
XANTENNA__2595__A2 _3870_/B1 vssd1 vssd1 vccd1 vccd1 sky130_fd_sc_hd__diode_2
XPHY_EDGE_ROW_86_Left_174 vssd1 vssd1 vccd1 vccd1 sky130_fd_sc_hd__decap_3
XFILLER_30_95 vssd1 vssd1 vccd1 vccd1 sky130_fd_sc_hd__decap_8
XFILLER_76_253 vssd1 vssd1 vccd1 vccd1 sky130_fd_sc_hd__decap_4
XTAP_TAPCELL_ROW_47_613 vssd1 vccd1 sky130_fd_sc_hd__tapvpwrvgnd_1
XTAP_TAPCELL_ROW_19_359 vssd1 vccd1 sky130_fd_sc_hd__tapvpwrvgnd_1
X_3760_ _3732_/X _3728_/Y _3759_/X vssd1 vssd1 vccd1 vccd1 _3767_/A sky130_fd_sc_hd__o21bai_2
X_2711_ _2711_/A _2711_/B vssd1 vssd1 vccd1 vccd1 _2724_/C sky130_fd_sc_hd__xnor2_1
X_3691_ _3661_/A _3661_/B _3726_/A vssd1 vssd1 vccd1 vccd1 _3691_/Y sky130_fd_sc_hd__a21oi_1
XFILLER_65_3 vssd1 vssd1 vccd1 vccd1 sky130_fd_sc_hd__fill_1
X_2642_ _2610_/A _2646_/B _2609_/B _2613_/A vssd1 vssd1 vccd1 vccd1 _2653_/A sky130_fd_sc_hd__o31ai_2
XTAP_TAPCELL_ROW_10_281 vssd1 vccd1 sky130_fd_sc_hd__tapvpwrvgnd_1
X_2573_ _4693_/Q _4680_/Q vssd1 vssd1 vccd1 vccd1 _2576_/A sky130_fd_sc_hd__and2_1
X_4312_ _4819_/Q _4373_/B _4371_/B vssd1 vssd1 vccd1 vccd1 _4312_/Y sky130_fd_sc_hd__nor3_1
X_4243_ _4238_/S _4243_/A2 _4361_/B1 vssd1 vssd1 vccd1 vccd1 _4243_/Y sky130_fd_sc_hd__a21oi_1
XFILLER_59_209 vccd1 vssd1 vccd1 vssd1 sky130_ef_sc_hd__decap_12
X_4174_ _4171_/X _4172_/X _4173_/Y _4295_/B1 hold115/X vssd1 vssd1 vccd1 vccd1 _4735_/D
+ sky130_fd_sc_hd__o32a_1
X_3125_ _3862_/C _3862_/D _3124_/B vssd1 vssd1 vccd1 vccd1 _3126_/C sky130_fd_sc_hd__a21o_1
XTAP_TAPCELL_ROW_2_205 vssd1 vccd1 sky130_fd_sc_hd__tapvpwrvgnd_1
X_3056_ _3054_/Y _3056_/B vssd1 vssd1 vccd1 vccd1 _3056_/Y sky130_fd_sc_hd__nand2b_1
XFILLER_82_278 vccd1 vssd1 vccd1 vssd1 sky130_ef_sc_hd__decap_12
XTAP_TAPCELL_ROW_81_914 vssd1 vccd1 sky130_fd_sc_hd__tapvpwrvgnd_1
XFILLER_35_150 vssd1 vssd1 vccd1 vccd1 sky130_fd_sc_hd__decap_3
XANTENNA_fanout424_A input2/X vssd1 vssd1 vccd1 vccd1 sky130_fd_sc_hd__diode_2
X_3958_ hold202/X _4007_/B2 _3957_/X vssd1 vssd1 vccd1 vccd1 _4679_/D sky130_fd_sc_hd__o21a_1
X_3889_ _4179_/B _4179_/C _4178_/D vssd1 vssd1 vccd1 vccd1 _3889_/X sky130_fd_sc_hd__and3_1
X_2909_ _4748_/Q _4718_/Q vssd1 vssd1 vccd1 vccd1 _2909_/Y sky130_fd_sc_hd__nand2_1
XANTENNA__4726__RESET_B fanout382/X vssd1 vssd1 vccd1 vccd1 sky130_fd_sc_hd__diode_2
XFILLER_76_36 vccd1 vssd1 vccd1 vssd1 sky130_ef_sc_hd__decap_12
XFILLER_73_201 vssd1 vssd1 vccd1 vccd1 sky130_fd_sc_hd__fill_1
XFILLER_46_415 vssd1 vssd1 vccd1 vccd1 sky130_fd_sc_hd__fill_1
XFILLER_58_253 vssd1 vssd1 vccd1 vccd1 sky130_fd_sc_hd__fill_2
XFILLER_73_267 vssd1 vssd1 vccd1 vccd1 sky130_fd_sc_hd__decap_4
XTAP_TAPCELL_ROW_16_329 vssd1 vccd1 sky130_fd_sc_hd__tapvpwrvgnd_1
XANTENNA__4006__A2 _4022_/A2 vssd1 vssd1 vccd1 vccd1 sky130_fd_sc_hd__diode_2
XTAP_TAPCELL_ROW_52_660 vssd1 vccd1 sky130_fd_sc_hd__tapvpwrvgnd_1
XANTENNA__4190__A1 _4210_/A1 vssd1 vssd1 vccd1 vccd1 sky130_fd_sc_hd__diode_2
XFILLER_49_220 vssd1 vssd1 vccd1 vccd1 sky130_fd_sc_hd__fill_1
XFILLER_49_253 vssd1 vssd1 vccd1 vccd1 sky130_fd_sc_hd__decap_8
XFILLER_49_297 vssd1 vssd1 vccd1 vccd1 sky130_fd_sc_hd__fill_1
XFILLER_17_194 vssd1 vssd1 vccd1 vccd1 sky130_fd_sc_hd__decap_3
X_3812_ _4624_/Q _3828_/A2 _2508_/X _3811_/Y vssd1 vssd1 vccd1 vccd1 _4624_/D sky130_fd_sc_hd__a22o_1
X_4792_ clkload3/A _4792_/D fanout375/X vssd1 vssd1 vccd1 vccd1 _4792_/Q sky130_fd_sc_hd__dfrtp_1
X_3743_ _3743_/A _3743_/B _3743_/C _3743_/D vssd1 vssd1 vccd1 vccd1 _3759_/D sky130_fd_sc_hd__or4_1
X_3674_ _3674_/A _3674_/B vssd1 vssd1 vccd1 vccd1 _3685_/A sky130_fd_sc_hd__nor2_1
X_2625_ _4520_/Q _3870_/B1 _2614_/Y _2624_/Y vssd1 vssd1 vccd1 vccd1 _4520_/D sky130_fd_sc_hd__o22a_1
XANTENNA__4181__A1 _4737_/Q vssd1 vssd1 vccd1 vccd1 sky130_fd_sc_hd__diode_2
X_2556_ _2516_/B _2516_/A _2514_/Y vssd1 vssd1 vccd1 vccd1 _2557_/A sky130_fd_sc_hd__o21ai_1
X_2487_ _2487_/A _2487_/B vssd1 vssd1 vccd1 vccd1 _2488_/B sky130_fd_sc_hd__or2_1
XFILLER_87_337 vccd1 vssd1 vccd1 vssd1 sky130_ef_sc_hd__decap_12
X_4226_ _4238_/A0 _4238_/A1 _4231_/C vssd1 vssd1 vccd1 vccd1 _4226_/X sky130_fd_sc_hd__mux2_1
XTAP_TAPCELL_ROW_58_708 vssd1 vccd1 sky130_fd_sc_hd__tapvpwrvgnd_1
X_4157_ _4356_/A _4176_/A2 _4280_/B2 vssd1 vssd1 vccd1 vccd1 _4157_/Y sky130_fd_sc_hd__o21ai_1
X_3108_ _3050_/C _3862_/C _3105_/Y _3106_/X vssd1 vssd1 vccd1 vccd1 _3108_/Y sky130_fd_sc_hd__a211oi_4
X_4088_ _4148_/C _4104_/B _4100_/C _4223_/C vssd1 vssd1 vccd1 vccd1 _4088_/X sky130_fd_sc_hd__and4b_1
X_3039_ _2988_/Y _2998_/A _3055_/A _3038_/X vssd1 vssd1 vccd1 vccd1 _3055_/B sky130_fd_sc_hd__o211ai_2
XTAP_TAPCELL_ROW_66_785 vssd1 vccd1 sky130_fd_sc_hd__tapvpwrvgnd_1
XFILLER_23_153 vssd1 vssd1 vccd1 vccd1 sky130_fd_sc_hd__fill_1
XFILLER_11_337 vssd1 vssd1 vccd1 vccd1 sky130_fd_sc_hd__fill_1
XFILLER_7_319 vccd1 vssd1 vccd1 vssd1 sky130_ef_sc_hd__decap_12
XTAP_TAPCELL_ROW_21_376 vssd1 vccd1 sky130_fd_sc_hd__tapvpwrvgnd_1
XFILLER_3_503 vssd1 vssd1 vccd1 vccd1 sky130_fd_sc_hd__fill_1
XANTENNA__4560__RESET_B fanout435/X vssd1 vssd1 vccd1 vccd1 sky130_fd_sc_hd__diode_2
XFILLER_87_57 vccd1 vssd1 vccd1 vssd1 sky130_ef_sc_hd__decap_12
Xfanout350 _4719_/Q vssd1 vssd1 vccd1 vccd1 _3023_/A sky130_fd_sc_hd__dlymetal6s2s_1
Xfanout372 _3784_/B1 vssd1 vssd1 vccd1 vccd1 _3311_/B sky130_fd_sc_hd__buf_1
Xfanout361 _3794_/A0 vssd1 vssd1 vccd1 vccd1 _3503_/A2 sky130_fd_sc_hd__clkbuf_4
Xfanout383 fanout388/X vssd1 vssd1 vccd1 vccd1 fanout383/X sky130_fd_sc_hd__clkbuf_4
Xfanout394 fanout395/X vssd1 vssd1 vccd1 vccd1 fanout394/X sky130_fd_sc_hd__clkbuf_4
XTAP_TAPCELL_ROW_29_454 vssd1 vccd1 sky130_fd_sc_hd__tapvpwrvgnd_1
XFILLER_14_120 vssd1 vssd1 vccd1 vccd1 sky130_fd_sc_hd__decap_8
Xinput25 s_axis_tdata[2] vssd1 vssd1 vccd1 vccd1 input25/X sky130_fd_sc_hd__clkbuf_1
Xinput14 s_axis_tdata[1] vssd1 vssd1 vccd1 vccd1 input14/X sky130_fd_sc_hd__clkbuf_1
Xinput36 s_axis_tvalid vssd1 vssd1 vccd1 vccd1 _3923_/B sky130_fd_sc_hd__clkbuf_1
X_2410_ hold52/X _2409_/X _2424_/S vssd1 vssd1 vccd1 vccd1 _4500_/D sky130_fd_sc_hd__mux2_1
XANTENNA__4163__A1 _4167_/A1 vssd1 vssd1 vccd1 vccd1 sky130_fd_sc_hd__diode_2
XFILLER_6_385 vssd1 vssd1 vccd1 vccd1 sky130_fd_sc_hd__decap_6
X_3390_ _4592_/Q _3424_/A2 _3541_/B1 _3613_/C vssd1 vssd1 vccd1 vccd1 _3390_/X sky130_fd_sc_hd__o211a_1
XFILLER_69_315 vssd1 vssd1 vccd1 vccd1 sky130_fd_sc_hd__decap_3
X_2341_ _2341_/A0 _2341_/A1 _4036_/S vssd1 vssd1 vccd1 vccd1 _2341_/X sky130_fd_sc_hd__mux2_1
X_2272_ hold83/X _4580_/Q _2272_/S vssd1 vssd1 vccd1 vccd1 _4451_/D sky130_fd_sc_hd__mux2_1
XFILLER_28_3 vssd1 vssd1 vccd1 vccd1 sky130_fd_sc_hd__decap_4
X_4011_ _4010_/Y _4009_/X _4008_/X hold94/X _4138_/B1 vssd1 vssd1 vccd1 vccd1 _4694_/D
+ sky130_fd_sc_hd__o32a_1
XANTENNA__4187__B _4211_/B vssd1 vssd1 vccd1 vccd1 sky130_fd_sc_hd__diode_2
XANTENNA__4407__S _4408_/S vssd1 vssd1 vccd1 vccd1 sky130_fd_sc_hd__diode_2
XTAP_TAPCELL_ROW_63_755 vssd1 vccd1 sky130_fd_sc_hd__tapvpwrvgnd_1
X_4775_ _4776_/CLK _4775_/D fanout399/X vssd1 vssd1 vccd1 vccd1 _4775_/Q sky130_fd_sc_hd__dfrtp_1
XANTENNA_fanout122_A _3890_/S vssd1 vssd1 vccd1 vccd1 sky130_fd_sc_hd__diode_2
X_3726_ _3726_/A _3727_/C vssd1 vssd1 vccd1 vccd1 _3726_/Y sky130_fd_sc_hd__nor2_1
X_3657_ _3657_/A _3657_/B _3657_/C vssd1 vssd1 vccd1 vccd1 _3661_/A sky130_fd_sc_hd__nand3_1
X_3588_ _3578_/A _3578_/B _3582_/Y vssd1 vssd1 vccd1 vccd1 _3588_/Y sky130_fd_sc_hd__o21ai_1
X_2608_ _4656_/Q _4754_/Q vssd1 vssd1 vccd1 vccd1 _2609_/B sky130_fd_sc_hd__nor2_1
XFILLER_0_517 vssd1 vssd1 vccd1 vccd1 sky130_fd_sc_hd__fill_2
X_2539_ _4737_/Q _4707_/Q vssd1 vssd1 vccd1 vccd1 _2539_/Y sky130_fd_sc_hd__nor2_1
X_4209_ _4208_/Y _4207_/X _4206_/X hold144/X _4209_/B2 vssd1 vssd1 vccd1 vccd1 _4744_/D
+ sky130_fd_sc_hd__o32a_1
XFILLER_83_362 vccd1 vssd1 vccd1 vssd1 sky130_ef_sc_hd__decap_12
XTAP_TAPCELL_ROW_26_424 vssd1 vccd1 sky130_fd_sc_hd__tapvpwrvgnd_1
XANTENNA__4145__A1 _4273_/S vssd1 vssd1 vccd1 vccd1 sky130_fd_sc_hd__diode_2
XANTENNA__3904__B _4001_/C vssd1 vssd1 vccd1 vccd1 sky130_fd_sc_hd__diode_2
Xfanout191 _3004_/B1 vssd1 vssd1 vccd1 vccd1 _3130_/A sky130_fd_sc_hd__buf_1
Xfanout180 _3889_/X vssd1 vssd1 vccd1 vccd1 _4214_/A0 sky130_fd_sc_hd__clkbuf_2
XFILLER_74_373 vssd1 vssd1 vccd1 vccd1 sky130_fd_sc_hd__fill_1
XANTENNA__3408__B1 _3541_/B1 vssd1 vssd1 vccd1 vccd1 sky130_fd_sc_hd__diode_2
XFILLER_30_421 vssd1 vssd1 vccd1 vccd1 sky130_fd_sc_hd__fill_2
X_2890_ _2836_/C _2840_/A _2838_/Y vssd1 vssd1 vccd1 vccd1 _2893_/C sky130_fd_sc_hd__a21o_1
XTAP_TAPCELL_ROW_60_725 vssd1 vccd1 sky130_fd_sc_hd__tapvpwrvgnd_1
X_4560_ _4562_/CLK _4560_/D fanout435/X vssd1 vssd1 vccd1 vccd1 _4560_/Q sky130_fd_sc_hd__dfrtp_2
X_3511_ _3511_/A _3511_/B _3511_/C vssd1 vssd1 vccd1 vccd1 _3512_/B sky130_fd_sc_hd__nand3_1
X_4491_ _4562_/CLK _4491_/D fanout432/X vssd1 vssd1 vccd1 vccd1 hold33/A sky130_fd_sc_hd__dfrtp_1
XPHY_EDGE_ROW_31_Left_119 vssd1 vssd1 vccd1 vccd1 sky130_fd_sc_hd__decap_3
X_3442_ _3442_/A _3442_/B vssd1 vssd1 vccd1 vccd1 _3442_/X sky130_fd_sc_hd__xor2_1
X_3373_ _4589_/Q _3424_/A2 _3541_/B1 _3925_/S vssd1 vssd1 vccd1 vccd1 _3373_/X sky130_fd_sc_hd__o211a_1
X_2324_ _4021_/D _2335_/C _2335_/B _3890_/S _2322_/X vssd1 vssd1 vccd1 vccd1 _2324_/X
+ sky130_fd_sc_hd__a311o_1
XFILLER_69_167 vssd1 vssd1 vccd1 vccd1 sky130_fd_sc_hd__fill_1
XTAP_TAPCELL_ROW_68_803 vssd1 vccd1 sky130_fd_sc_hd__tapvpwrvgnd_1
X_2255_ hold81/X _4563_/Q _2272_/S vssd1 vssd1 vccd1 vccd1 _4434_/D sky130_fd_sc_hd__mux2_1
XFILLER_65_373 vssd1 vssd1 vccd1 vccd1 sky130_fd_sc_hd__decap_6
XPHY_EDGE_ROW_40_Left_128 vssd1 vssd1 vccd1 vccd1 sky130_fd_sc_hd__decap_3
XFILLER_33_281 vssd1 vssd1 vccd1 vccd1 sky130_fd_sc_hd__fill_2
XFILLER_21_432 vssd1 vssd1 vccd1 vccd1 sky130_fd_sc_hd__fill_2
XTAP_TAPCELL_ROW_31_471 vssd1 vccd1 sky130_fd_sc_hd__tapvpwrvgnd_1
XANTENNA_fanout125_X _3975_/S vssd1 vssd1 vccd1 vccd1 sky130_fd_sc_hd__diode_2
X_4758_ _4776_/CLK _4758_/D fanout399/X vssd1 vssd1 vccd1 vccd1 _4758_/Q sky130_fd_sc_hd__dfrtp_1
X_4689_ _4794_/CLK _4689_/D fanout377/X vssd1 vssd1 vccd1 vccd1 _4689_/Q sky130_fd_sc_hd__dfrtp_1
X_3709_ _3709_/A _3729_/C vssd1 vssd1 vccd1 vccd1 _3709_/Y sky130_fd_sc_hd__nand2_1
XANTENNA__4127__A1 _4171_/A1 vssd1 vssd1 vccd1 vccd1 sky130_fd_sc_hd__diode_2
XFILLER_0_325 vssd1 vssd1 vccd1 vccd1 sky130_fd_sc_hd__fill_1
XANTENNA__3886__A0 _4167_/A0 vssd1 vssd1 vccd1 vccd1 sky130_fd_sc_hd__diode_2
XANTENNA__4258__D _4324_/A vssd1 vssd1 vccd1 vccd1 sky130_fd_sc_hd__diode_2
XFILLER_84_69 vssd1 vssd1 vccd1 vccd1 sky130_fd_sc_hd__fill_1
XANTENNA__4047__S _4120_/D vssd1 vssd1 vccd1 vccd1 sky130_fd_sc_hd__diode_2
XFILLER_56_351 vssd1 vssd1 vccd1 vccd1 sky130_fd_sc_hd__fill_1
XANTENNA__4063__A0 _4099_/A0 vssd1 vssd1 vccd1 vccd1 sky130_fd_sc_hd__diode_2
XFILLER_12_421 vccd1 vssd1 vccd1 vssd1 sky130_ef_sc_hd__decap_12
XFILLER_8_436 vssd1 vssd1 vccd1 vccd1 sky130_fd_sc_hd__decap_8
XFILLER_33_84 vssd1 vssd1 vccd1 vccd1 sky130_fd_sc_hd__fill_2
Xhold3 hold3/A vssd1 vssd1 vccd1 vccd1 hold3/X sky130_fd_sc_hd__dlygate4sd3_1
XTAP_TAPCELL_ROW_37_519 vssd1 vccd1 sky130_fd_sc_hd__tapvpwrvgnd_1
XANTENNA_clkbuf_leaf_11_clk_A clkload1/A vssd1 vssd1 vccd1 vccd1 sky130_fd_sc_hd__diode_2
XTAP_TAPCELL_ROW_73_850 vssd1 vccd1 sky130_fd_sc_hd__tapvpwrvgnd_1
X_3991_ _3990_/Y _3989_/X _3988_/X hold147/X _4058_/B2 vssd1 vssd1 vccd1 vccd1 _4689_/D
+ sky130_fd_sc_hd__o32a_1
XANTENNA_clkbuf_leaf_26_clk_A clkbuf_2_3__f_clk/X vssd1 vssd1 vccd1 vccd1 sky130_fd_sc_hd__diode_2
X_2942_ _2942_/A _2942_/B vssd1 vssd1 vccd1 vccd1 _2944_/B sky130_fd_sc_hd__or2_1
XFILLER_22_218 vssd1 vssd1 vccd1 vccd1 sky130_fd_sc_hd__fill_1
XTAP_TAPCELL_ROW_45_596 vssd1 vccd1 sky130_fd_sc_hd__tapvpwrvgnd_1
X_2873_ _2873_/A _3862_/B vssd1 vssd1 vccd1 vccd1 _2873_/Y sky130_fd_sc_hd__nand2_1
X_4612_ _4612_/CLK _4612_/D fanout430/X vssd1 vssd1 vccd1 vccd1 _4612_/Q sky130_fd_sc_hd__dfrtp_2
X_4543_ _4549_/CLK _4543_/D fanout416/X vssd1 vssd1 vccd1 vccd1 _4543_/Q sky130_fd_sc_hd__dfrtp_1
XANTENNA__4109__B2 _4107_/X vssd1 vssd1 vccd1 vccd1 sky130_fd_sc_hd__diode_2
X_4474_ _4546_/CLK _4474_/D fanout417/X vssd1 vssd1 vccd1 vccd1 hold20/A sky130_fd_sc_hd__dfrtp_1
X_3425_ _4557_/Q _3425_/A2 _3423_/X _3424_/X vssd1 vssd1 vccd1 vccd1 _4557_/D sky130_fd_sc_hd__a22o_1
X_3356_ _4586_/Q _3384_/A2 _3395_/B1 _3367_/C1 vssd1 vssd1 vccd1 vccd1 _3356_/X sky130_fd_sc_hd__o211a_1
X_2307_ _4005_/D _2323_/B vssd1 vssd1 vccd1 vccd1 _2307_/Y sky130_fd_sc_hd__nor2_1
X_3287_ _3282_/A _4589_/Q _3285_/Y vssd1 vssd1 vccd1 vccd1 _3287_/Y sky130_fd_sc_hd__o21ai_1
XFILLER_85_446 vssd1 vssd1 vccd1 vccd1 sky130_fd_sc_hd__fill_2
X_2238_ hold29/X _4546_/Q _2242_/S vssd1 vssd1 vccd1 vccd1 _4417_/D sky130_fd_sc_hd__mux2_1
XANTENNA_fanout287_A _4009_/A_N vssd1 vssd1 vccd1 vccd1 sky130_fd_sc_hd__diode_2
XFILLER_53_332 vssd1 vssd1 vccd1 vccd1 sky130_fd_sc_hd__fill_1
XTAP_TAPCELL_ROW_0_177 vssd1 vccd1 sky130_fd_sc_hd__tapvpwrvgnd_1
XTAP_TAPCELL_ROW_0_188 vssd1 vccd1 sky130_fd_sc_hd__tapvpwrvgnd_1
XFILLER_41_505 vssd1 vssd1 vccd1 vccd1 sky130_fd_sc_hd__fill_1
XFILLER_13_229 vssd1 vssd1 vccd1 vccd1 sky130_fd_sc_hd__fill_1
XANTENNA_fanout242_X _2369_/S vssd1 vssd1 vccd1 vccd1 sky130_fd_sc_hd__diode_2
XFILLER_53_376 vssd1 vssd1 vccd1 vccd1 sky130_fd_sc_hd__decap_3
XFILLER_79_69 vccd1 vssd1 vccd1 vssd1 sky130_ef_sc_hd__decap_12
XFILLER_0_111 vssd1 vssd1 vccd1 vccd1 sky130_fd_sc_hd__fill_1
XFILLER_48_115 vssd1 vssd1 vccd1 vccd1 sky130_fd_sc_hd__fill_1
XTAP_TAPCELL_ROW_87_975 vssd1 vccd1 sky130_fd_sc_hd__tapvpwrvgnd_1
XFILLER_63_118 vssd1 vssd1 vccd1 vccd1 sky130_fd_sc_hd__decap_8
XANTENNA_input15_A s_axis_tdata[20] vssd1 vssd1 vccd1 vccd1 sky130_fd_sc_hd__diode_2
XFILLER_28_95 vssd1 vssd1 vccd1 vccd1 sky130_fd_sc_hd__decap_4
XFILLER_44_321 vssd1 vssd1 vccd1 vccd1 sky130_fd_sc_hd__decap_4
XFILLER_56_170 vssd1 vssd1 vccd1 vccd1 sky130_fd_sc_hd__fill_2
XFILLER_44_343 vccd1 vssd1 vccd1 vssd1 sky130_ef_sc_hd__decap_12
XFILLER_44_365 vssd1 vssd1 vccd1 vccd1 sky130_fd_sc_hd__decap_8
XTAP_TAPCELL_ROW_70_820 vssd1 vccd1 sky130_fd_sc_hd__tapvpwrvgnd_1
XANTENNA__4802__Q _4802_/Q vssd1 vssd1 vccd1 vccd1 sky130_fd_sc_hd__diode_2
XFILLER_12_251 vssd1 vssd1 vccd1 vccd1 sky130_fd_sc_hd__fill_1
XTAP_TAPCELL_ROW_42_566 vssd1 vccd1 sky130_fd_sc_hd__tapvpwrvgnd_1
XFILLER_8_244 vssd1 vssd1 vccd1 vccd1 sky130_fd_sc_hd__fill_1
XFILLER_5_55 vssd1 vssd1 vccd1 vccd1 sky130_fd_sc_hd__fill_1
XFILLER_4_461 vccd1 vssd1 vccd1 vssd1 sky130_ef_sc_hd__decap_12
X_4190_ _4214_/A0 _4210_/A1 _4323_/S vssd1 vssd1 vccd1 vccd1 _4190_/X sky130_fd_sc_hd__mux2_1
X_3210_ _4558_/Q _4599_/Q _3437_/A _3209_/X _3432_/A vssd1 vssd1 vccd1 vccd1 _3213_/A
+ sky130_fd_sc_hd__o2111a_1
X_3141_ _3142_/B _4787_/Q vssd1 vssd1 vccd1 vccd1 _3865_/A sky130_fd_sc_hd__nand2_1
XFILLER_67_413 vssd1 vssd1 vccd1 vccd1 sky130_fd_sc_hd__fill_1
XFILLER_67_468 vccd1 vssd1 vccd1 vssd1 sky130_ef_sc_hd__decap_12
XFILLER_67_446 vssd1 vssd1 vccd1 vccd1 sky130_fd_sc_hd__fill_2
X_3072_ _4769_/Q _4784_/Q vssd1 vssd1 vccd1 vccd1 _3074_/A sky130_fd_sc_hd__and2_1
XANTENNA__4195__B _4211_/B vssd1 vssd1 vccd1 vccd1 sky130_fd_sc_hd__diode_2
XFILLER_23_505 vssd1 vssd1 vccd1 vccd1 sky130_fd_sc_hd__fill_1
X_3974_ _3873_/A _3974_/A1 _4036_/S vssd1 vssd1 vccd1 vccd1 _3974_/X sky130_fd_sc_hd__mux2_1
X_2925_ _2893_/C _2893_/Y _2923_/Y _2924_/X vssd1 vssd1 vccd1 vccd1 _2927_/A sky130_fd_sc_hd__a211o_1
X_2856_ _2857_/B _2857_/C _2857_/A vssd1 vssd1 vccd1 vccd1 _2858_/A sky130_fd_sc_hd__a21oi_1
X_2787_ _2785_/X _2786_/X _2743_/C _2745_/A vssd1 vssd1 vccd1 vccd1 _2790_/A sky130_fd_sc_hd__o211ai_1
Xhold211 _4729_/Q vssd1 vssd1 vccd1 vccd1 hold211/X sky130_fd_sc_hd__dlygate4sd3_1
Xhold200 _4760_/Q vssd1 vssd1 vccd1 vccd1 hold200/X sky130_fd_sc_hd__dlygate4sd3_1
Xhold222 _4597_/Q vssd1 vssd1 vccd1 vccd1 hold222/X sky130_fd_sc_hd__dlygate4sd3_1
X_4526_ _4635_/CLK _4526_/D fanout425/X vssd1 vssd1 vccd1 vccd1 _4526_/Q sky130_fd_sc_hd__dfrtp_1
X_4457_ _4808_/CLK _4457_/D fanout377/X vssd1 vssd1 vccd1 vccd1 _4457_/Q sky130_fd_sc_hd__dfrtp_1
XANTENNA__2761__B1 _2797_/A2 vssd1 vssd1 vccd1 vccd1 sky130_fd_sc_hd__diode_2
X_3408_ _4595_/Q _3424_/A2 _3541_/B1 _3613_/C vssd1 vssd1 vccd1 vccd1 _3408_/X sky130_fd_sc_hd__o211a_1
XANTENNA_input7_A s_axis_tdata[13] vssd1 vssd1 vccd1 vccd1 sky130_fd_sc_hd__diode_2
XFILLER_85_210 vssd1 vssd1 vccd1 vccd1 sky130_fd_sc_hd__decap_4
X_4388_ _4219_/C input34/X _4408_/S vssd1 vssd1 vccd1 vccd1 _4797_/D sky130_fd_sc_hd__mux2_1
XTAP_TAPCELL_ROW_5_236 vssd1 vccd1 sky130_fd_sc_hd__tapvpwrvgnd_1
XFILLER_85_221 vssd1 vssd1 vccd1 vccd1 sky130_fd_sc_hd__decap_3
X_3339_ _3338_/A _3338_/B _4541_/Q _4582_/Q vssd1 vssd1 vccd1 vccd1 _3339_/X sky130_fd_sc_hd__a2bb2o_1
XFILLER_58_457 vssd1 vssd1 vccd1 vccd1 sky130_fd_sc_hd__fill_1
XFILLER_73_427 vccd1 vssd1 vccd1 vssd1 sky130_ef_sc_hd__decap_12
XTAP_TAPCELL_ROW_84_945 vssd1 vccd1 sky130_fd_sc_hd__tapvpwrvgnd_1
XFILLER_73_449 vssd1 vssd1 vccd1 vccd1 sky130_fd_sc_hd__decap_3
XFILLER_26_365 vssd1 vssd1 vccd1 vccd1 sky130_fd_sc_hd__decap_4
XFILLER_81_493 vssd1 vssd1 vccd1 vccd1 sky130_fd_sc_hd__decap_8
XFILLER_81_59 vssd1 vssd1 vccd1 vccd1 sky130_fd_sc_hd__decap_8
XFILLER_5_269 vssd1 vssd1 vccd1 vccd1 sky130_fd_sc_hd__decap_8
XFILLER_49_413 vssd1 vssd1 vccd1 vccd1 sky130_fd_sc_hd__fill_1
XFILLER_76_221 vssd1 vssd1 vccd1 vccd1 sky130_fd_sc_hd__decap_8
XFILLER_76_265 vccd1 vssd1 vccd1 vssd1 sky130_ef_sc_hd__decap_12
XTAP_TAPCELL_ROW_47_614 vssd1 vccd1 sky130_fd_sc_hd__tapvpwrvgnd_1
XFILLER_32_324 vccd1 vssd1 vccd1 vssd1 sky130_ef_sc_hd__decap_12
XTAP_TAPCELL_ROW_55_680 vssd1 vccd1 sky130_fd_sc_hd__tapvpwrvgnd_1
XANTENNA__3783__A2 _3735_/S vssd1 vssd1 vccd1 vccd1 sky130_fd_sc_hd__diode_2
XFILLER_71_81 vssd1 vssd1 vccd1 vccd1 sky130_fd_sc_hd__decap_8
X_2710_ _4727_/Q _2710_/B vssd1 vssd1 vccd1 vccd1 _2711_/B sky130_fd_sc_hd__xnor2_2
X_3690_ _3690_/A _3690_/B _3690_/C _3727_/B vssd1 vssd1 vccd1 vccd1 _3726_/A sky130_fd_sc_hd__or4_1
X_2641_ _2641_/A _2641_/B vssd1 vssd1 vccd1 vccd1 _3821_/A sky130_fd_sc_hd__xor2_1
XTAP_TAPCELL_ROW_10_282 vssd1 vccd1 sky130_fd_sc_hd__tapvpwrvgnd_1
X_2572_ _2572_/A _2617_/B vssd1 vssd1 vccd1 vccd1 _2580_/C sky130_fd_sc_hd__nand2_1
XFILLER_58_3 vssd1 vssd1 vccd1 vccd1 sky130_fd_sc_hd__decap_4
X_4311_ _4770_/Q _4361_/B1 _4310_/Y _4309_/X vssd1 vssd1 vccd1 vccd1 _4770_/D sky130_fd_sc_hd__a22o_1
X_4242_ _4179_/C _4178_/D _4179_/B _4238_/S vssd1 vssd1 vccd1 vccd1 _4242_/X sky130_fd_sc_hd__a22o_1
X_4173_ _4372_/A _4173_/A2 _4295_/B1 vssd1 vssd1 vccd1 vccd1 _4173_/Y sky130_fd_sc_hd__o21ai_1
X_3124_ _3145_/A _3124_/B vssd1 vssd1 vccd1 vccd1 _3126_/B sky130_fd_sc_hd__nand2_1
XFILLER_67_276 vssd1 vssd1 vccd1 vccd1 sky130_fd_sc_hd__decap_4
XTAP_TAPCELL_ROW_2_206 vssd1 vccd1 sky130_fd_sc_hd__tapvpwrvgnd_1
X_3055_ _3055_/A _3055_/B _3055_/C vssd1 vssd1 vccd1 vccd1 _3056_/B sky130_fd_sc_hd__nand3_1
XFILLER_82_246 vssd1 vssd1 vccd1 vccd1 sky130_fd_sc_hd__fill_1
XTAP_TAPCELL_ROW_81_915 vssd1 vccd1 sky130_fd_sc_hd__tapvpwrvgnd_1
Xclkbuf_leaf_47_clk clkload0/A vssd1 vssd1 vccd1 vccd1 _4686_/CLK sky130_fd_sc_hd__clkbuf_8
X_3957_ _4021_/D _3974_/A1 _3956_/Y _3886_/S vssd1 vssd1 vccd1 vccd1 _3957_/X sky130_fd_sc_hd__a211o_1
XFILLER_50_143 vssd1 vssd1 vccd1 vccd1 sky130_fd_sc_hd__fill_1
X_2908_ _4748_/Q _4718_/Q vssd1 vssd1 vccd1 vccd1 _2911_/C sky130_fd_sc_hd__and2_1
X_3888_ _4231_/D _4239_/B vssd1 vssd1 vccd1 vccd1 _4179_/C sky130_fd_sc_hd__nand2_1
XFILLER_31_390 vssd1 vssd1 vccd1 vccd1 sky130_fd_sc_hd__fill_2
X_2839_ _4761_/Q _4776_/Q vssd1 vssd1 vccd1 vccd1 _2840_/C sky130_fd_sc_hd__xor2_1
X_4509_ _4669_/CLK _4509_/D fanout408/X vssd1 vssd1 vccd1 vccd1 _4509_/Q sky130_fd_sc_hd__dfrtp_1
XFILLER_76_48 vccd1 vssd1 vccd1 vssd1 sky130_ef_sc_hd__decap_12
XFILLER_58_221 vssd1 vssd1 vccd1 vccd1 sky130_fd_sc_hd__decap_8
XFILLER_73_213 vssd1 vssd1 vccd1 vccd1 sky130_fd_sc_hd__decap_4
XANTENNA__4266__D _4266_/D vssd1 vssd1 vccd1 vccd1 sky130_fd_sc_hd__diode_2
Xclkbuf_leaf_38_clk clkload2/A vssd1 vssd1 vccd1 vccd1 _4546_/CLK sky130_fd_sc_hd__clkbuf_8
XANTENNA__4055__S _4123_/S vssd1 vssd1 vccd1 vccd1 sky130_fd_sc_hd__diode_2
XFILLER_25_52 vssd1 vssd1 vccd1 vccd1 sky130_fd_sc_hd__fill_1
XFILLER_41_110 vssd1 vssd1 vccd1 vccd1 sky130_fd_sc_hd__fill_2
XTAP_TAPCELL_ROW_52_661 vssd1 vccd1 sky130_fd_sc_hd__tapvpwrvgnd_1
XANTENNA__3894__S _4314_/S vssd1 vssd1 vccd1 vccd1 sky130_fd_sc_hd__diode_2
XFILLER_6_501 vssd1 vssd1 vccd1 vccd1 sky130_fd_sc_hd__decap_8
XANTENNA__3923__A _3923_/A vssd1 vssd1 vccd1 vccd1 sky130_fd_sc_hd__diode_2
XANTENNA__2539__A _4737_/Q vssd1 vssd1 vccd1 vccd1 sky130_fd_sc_hd__diode_2
XANTENNA__4436__RESET_B fanout435/X vssd1 vssd1 vccd1 vccd1 sky130_fd_sc_hd__diode_2
XFILLER_37_405 vccd1 vssd1 vccd1 vssd1 sky130_ef_sc_hd__decap_12
XFILLER_64_213 vssd1 vssd1 vccd1 vccd1 sky130_fd_sc_hd__fill_1
Xclkbuf_leaf_29_clk clkbuf_2_3__f_clk/X vssd1 vssd1 vccd1 vccd1 _4579_/CLK sky130_fd_sc_hd__clkbuf_8
XANTENNA__2274__A _2274_/A vssd1 vssd1 vccd1 vccd1 sky130_fd_sc_hd__diode_2
XFILLER_32_132 vssd1 vssd1 vccd1 vccd1 sky130_fd_sc_hd__decap_8
X_3811_ _3811_/A _3811_/B vssd1 vssd1 vccd1 vccd1 _3811_/Y sky130_fd_sc_hd__nand2_1
XFILLER_32_143 vccd1 vssd1 vccd1 vssd1 sky130_ef_sc_hd__decap_12
X_4791_ clkload3/A _4791_/D fanout375/X vssd1 vssd1 vccd1 vccd1 _4791_/Q sky130_fd_sc_hd__dfrtp_1
X_3742_ _4532_/Q _4641_/Q _3743_/A vssd1 vssd1 vccd1 vccd1 _3742_/Y sky130_fd_sc_hd__a21oi_1
X_3673_ _4525_/Q _4634_/Q vssd1 vssd1 vccd1 vccd1 _3674_/B sky130_fd_sc_hd__nor2_1
X_2624_ _2615_/Y _2623_/Y _3870_/B1 vssd1 vssd1 vccd1 vccd1 _2624_/Y sky130_fd_sc_hd__o21ai_1
X_2555_ _2522_/A _2522_/B _2522_/D _2519_/X vssd1 vssd1 vccd1 vccd1 _2561_/B sky130_fd_sc_hd__o31ai_1
XFILLER_87_305 vssd1 vssd1 vccd1 vccd1 sky130_fd_sc_hd__decap_3
X_2486_ _2487_/A _2487_/B vssd1 vssd1 vccd1 vccd1 _2502_/A sky130_fd_sc_hd__nand2_1
XFILLER_87_349 vccd1 vssd1 vccd1 vssd1 sky130_ef_sc_hd__decap_12
X_4225_ _4224_/Y _4223_/X _4222_/X hold188/X _4225_/B2 vssd1 vssd1 vccd1 vccd1 _4748_/D
+ sky130_fd_sc_hd__o32a_1
X_4156_ _4239_/D _4172_/B _4175_/C _4223_/C vssd1 vssd1 vccd1 vccd1 _4156_/X sky130_fd_sc_hd__and4b_1
XTAP_TAPCELL_ROW_58_709 vssd1 vccd1 sky130_fd_sc_hd__tapvpwrvgnd_1
X_3107_ _3025_/A _3049_/Y _3105_/Y _3106_/X _3050_/C vssd1 vssd1 vccd1 vccd1 _3107_/X
+ sky130_fd_sc_hd__o221a_2
X_4087_ _4103_/A0 _4103_/A1 _4087_/S vssd1 vssd1 vccd1 vccd1 _4087_/X sky130_fd_sc_hd__mux2_1
X_3038_ _4765_/Q _4780_/Q _3033_/A _3008_/B _3037_/B vssd1 vssd1 vccd1 vccd1 _3038_/X
+ sky130_fd_sc_hd__a311o_1
XTAP_TAPCELL_ROW_66_786 vssd1 vccd1 sky130_fd_sc_hd__tapvpwrvgnd_1
XFILLER_23_165 vssd1 vssd1 vccd1 vccd1 sky130_fd_sc_hd__decap_3
XFILLER_51_441 vssd1 vssd1 vccd1 vccd1 sky130_fd_sc_hd__decap_6
XFILLER_11_316 vccd1 vssd1 vccd1 vssd1 sky130_ef_sc_hd__decap_12
XTAP_TAPCELL_ROW_21_377 vssd1 vccd1 sky130_fd_sc_hd__tapvpwrvgnd_1
XFILLER_11_65 vssd1 vssd1 vccd1 vccd1 sky130_fd_sc_hd__fill_1
XFILLER_87_69 vssd1 vssd1 vccd1 vccd1 sky130_fd_sc_hd__fill_2
Xfanout340 _4253_/S vssd1 vssd1 vccd1 vccd1 _4324_/A sky130_fd_sc_hd__buf_2
Xfanout373 _4613_/Q vssd1 vssd1 vccd1 vccd1 _3784_/B1 sky130_fd_sc_hd__buf_1
Xfanout384 fanout388/X vssd1 vssd1 vccd1 vccd1 fanout384/X sky130_fd_sc_hd__clkbuf_2
Xfanout362 _4615_/Q vssd1 vssd1 vccd1 vccd1 _3794_/A0 sky130_fd_sc_hd__clkbuf_2
Xfanout351 _2770_/A vssd1 vssd1 vccd1 vccd1 _2869_/B sky130_fd_sc_hd__clkbuf_2
Xfanout395 fanout398/X vssd1 vssd1 vccd1 vccd1 fanout395/X sky130_fd_sc_hd__clkbuf_2
XFILLER_61_227 vssd1 vssd1 vccd1 vccd1 sky130_fd_sc_hd__fill_1
XANTENNA__3986__A2 _4022_/A2 vssd1 vssd1 vccd1 vccd1 sky130_fd_sc_hd__diode_2
XFILLER_42_430 vccd1 vssd1 vccd1 vssd1 sky130_ef_sc_hd__decap_12
XTAP_TAPCELL_ROW_12_300 vssd1 vccd1 sky130_fd_sc_hd__tapvpwrvgnd_1
XFILLER_42_485 vssd1 vssd1 vccd1 vccd1 sky130_fd_sc_hd__fill_1
Xinput26 s_axis_tdata[30] vssd1 vssd1 vccd1 vccd1 input26/X sky130_fd_sc_hd__clkbuf_1
Xinput15 s_axis_tdata[20] vssd1 vssd1 vccd1 vccd1 input15/X sky130_fd_sc_hd__clkbuf_1
XANTENNA__4810__Q _4810_/Q vssd1 vssd1 vccd1 vccd1 sky130_fd_sc_hd__diode_2
X_2340_ _4037_/C _2340_/B _4036_/S vssd1 vssd1 vccd1 vccd1 _2340_/X sky130_fd_sc_hd__or3b_1
X_2271_ hold75/X _4579_/Q _2271_/S vssd1 vssd1 vccd1 vccd1 _4450_/D sky130_fd_sc_hd__mux2_1
X_4010_ _4071_/S _4038_/A2 _4138_/B1 vssd1 vssd1 vccd1 vccd1 _4010_/Y sky130_fd_sc_hd__o21ai_1
XANTENNA__4187__C _4199_/D vssd1 vssd1 vccd1 vccd1 sky130_fd_sc_hd__diode_2
XFILLER_77_393 vccd1 vssd1 vccd1 vssd1 sky130_ef_sc_hd__decap_12
XFILLER_37_202 vssd1 vssd1 vccd1 vccd1 sky130_fd_sc_hd__decap_8
XFILLER_37_257 vccd1 vssd1 vccd1 vssd1 sky130_ef_sc_hd__decap_12
XTAP_TAPCELL_ROW_63_756 vssd1 vccd1 sky130_fd_sc_hd__tapvpwrvgnd_1
XFILLER_20_124 vssd1 vssd1 vccd1 vccd1 sky130_fd_sc_hd__fill_1
X_4774_ _4774_/CLK _4774_/D fanout401/X vssd1 vssd1 vccd1 vccd1 _4774_/Q sky130_fd_sc_hd__dfrtp_1
X_3725_ _3725_/A _3725_/B _3729_/B _3716_/Y vssd1 vssd1 vccd1 vccd1 _3727_/C sky130_fd_sc_hd__or4b_1
XFILLER_9_191 vssd1 vssd1 vccd1 vccd1 sky130_fd_sc_hd__fill_2
XANTENNA__4037__A_N _3976_/D vssd1 vssd1 vccd1 vccd1 sky130_fd_sc_hd__diode_2
Xclkbuf_leaf_9_clk clkload1/A vssd1 vssd1 vccd1 vccd1 _4744_/CLK sky130_fd_sc_hd__clkbuf_8
XANTENNA_fanout115_A _2797_/A2 vssd1 vssd1 vccd1 vccd1 sky130_fd_sc_hd__diode_2
X_3656_ _3656_/A _3656_/B _3656_/C vssd1 vssd1 vccd1 vccd1 _3657_/B sky130_fd_sc_hd__and3_1
X_3587_ _3587_/A _3587_/B vssd1 vssd1 vccd1 vccd1 _3587_/Y sky130_fd_sc_hd__nor2_1
X_2607_ _4656_/Q _4754_/Q vssd1 vssd1 vccd1 vccd1 _2646_/B sky130_fd_sc_hd__and2_1
XANTENNA__3901__A2 _3975_/S vssd1 vssd1 vccd1 vccd1 sky130_fd_sc_hd__diode_2
X_2538_ _4737_/Q _4707_/Q vssd1 vssd1 vccd1 vccd1 _2588_/A sky130_fd_sc_hd__nand2_1
XFILLER_87_113 vccd1 vssd1 vccd1 vssd1 sky130_ef_sc_hd__decap_12
XANTENNA__4187__A_N _4258_/C vssd1 vssd1 vccd1 vccd1 sky130_fd_sc_hd__diode_2
X_2469_ _2473_/A _2473_/B vssd1 vssd1 vccd1 vccd1 _2474_/A sky130_fd_sc_hd__or2_1
X_4208_ _4340_/A _4212_/A2 _4208_/B1 vssd1 vssd1 vccd1 vccd1 _4208_/Y sky130_fd_sc_hd__o21ai_1
XFILLER_28_257 vssd1 vssd1 vccd1 vccd1 sky130_fd_sc_hd__decap_8
XANTENNA_fanout272_X _4136_/B vssd1 vssd1 vccd1 vccd1 sky130_fd_sc_hd__diode_2
X_4139_ _4171_/A0 _4167_/A1 _4273_/S vssd1 vssd1 vccd1 vccd1 _4139_/X sky130_fd_sc_hd__mux2_1
XFILLER_83_374 vccd1 vssd1 vccd1 vssd1 sky130_ef_sc_hd__decap_12
XFILLER_71_514 vssd1 vssd1 vccd1 vccd1 sky130_fd_sc_hd__fill_1
XTAP_TAPCELL_ROW_26_425 vssd1 vccd1 sky130_fd_sc_hd__tapvpwrvgnd_1
XTAP_TAPCELL_ROW_34_491 vssd1 vccd1 sky130_fd_sc_hd__tapvpwrvgnd_1
XFILLER_11_157 vssd1 vssd1 vccd1 vccd1 sky130_fd_sc_hd__decap_8
XFILLER_22_53 vssd1 vssd1 vccd1 vccd1 sky130_fd_sc_hd__decap_8
XFILLER_3_345 vccd1 vssd1 vccd1 vssd1 sky130_ef_sc_hd__decap_12
XANTENNA__4145__A2 _4176_/A2 vssd1 vssd1 vccd1 vccd1 sky130_fd_sc_hd__diode_2
XFILLER_3_389 vssd1 vssd1 vccd1 vccd1 sky130_fd_sc_hd__decap_3
Xfanout181 _3889_/X vssd1 vssd1 vccd1 vccd1 _4238_/A0 sky130_fd_sc_hd__dlymetal6s2s_1
Xfanout192 _2920_/Y vssd1 vssd1 vccd1 vccd1 _3004_/B1 sky130_fd_sc_hd__buf_1
Xfanout170 _4044_/X vssd1 vssd1 vccd1 vccd1 _4083_/A1 sky130_fd_sc_hd__buf_2
XFILLER_15_430 vssd1 vssd1 vccd1 vccd1 sky130_fd_sc_hd__fill_2
XANTENNA__4081__A1 _4215_/C vssd1 vssd1 vccd1 vccd1 sky130_fd_sc_hd__diode_2
XTAP_TAPCELL_ROW_60_726 vssd1 vccd1 sky130_fd_sc_hd__tapvpwrvgnd_1
X_3510_ _3511_/A _3511_/B _3511_/C vssd1 vssd1 vccd1 vccd1 _3510_/Y sky130_fd_sc_hd__a21oi_1
XFILLER_8_77 vssd1 vssd1 vccd1 vccd1 sky130_fd_sc_hd__fill_1
X_4490_ _4579_/CLK _4490_/D fanout432/X vssd1 vssd1 vccd1 vccd1 hold30/A sky130_fd_sc_hd__dfrtp_1
X_3441_ _3289_/Y _3295_/D _3213_/X vssd1 vssd1 vccd1 vccd1 _3442_/B sky130_fd_sc_hd__a21oi_2
X_3372_ _3383_/A1 _3371_/X _3383_/B1 vssd1 vssd1 vccd1 vccd1 _3372_/X sky130_fd_sc_hd__a21o_1
XFILLER_40_3 vssd1 vssd1 vccd1 vccd1 sky130_fd_sc_hd__fill_1
XFILLER_69_113 vssd1 vssd1 vccd1 vccd1 sky130_fd_sc_hd__fill_2
X_2323_ _4021_/D _2323_/B vssd1 vssd1 vccd1 vccd1 _2323_/Y sky130_fd_sc_hd__nor2_1
XTAP_TAPCELL_ROW_68_804 vssd1 vccd1 sky130_fd_sc_hd__tapvpwrvgnd_1
X_2254_ hold54/X _4562_/Q _2272_/S vssd1 vssd1 vccd1 vccd1 _4433_/D sky130_fd_sc_hd__mux2_1
XTAP_TAPCELL_ROW_76_870 vssd1 vccd1 sky130_fd_sc_hd__tapvpwrvgnd_1
XFILLER_25_205 vssd1 vssd1 vccd1 vccd1 sky130_fd_sc_hd__fill_1
XFILLER_25_216 vssd1 vssd1 vccd1 vccd1 sky130_fd_sc_hd__fill_2
XFILLER_25_249 vssd1 vssd1 vccd1 vccd1 sky130_fd_sc_hd__decap_8
XANTENNA_fanout232_A _4328_/B vssd1 vssd1 vccd1 vccd1 sky130_fd_sc_hd__diode_2
XANTENNA__3992__S _4064_/D vssd1 vssd1 vccd1 vccd1 sky130_fd_sc_hd__diode_2
XANTENNA__3583__B1 _3613_/B vssd1 vssd1 vccd1 vccd1 sky130_fd_sc_hd__diode_2
XTAP_TAPCELL_ROW_31_472 vssd1 vccd1 sky130_fd_sc_hd__tapvpwrvgnd_1
X_4757_ _4776_/CLK _4757_/D fanout399/X vssd1 vssd1 vccd1 vccd1 _4757_/Q sky130_fd_sc_hd__dfrtp_1
X_4688_ _4806_/CLK _4688_/D fanout385/X vssd1 vssd1 vccd1 vccd1 _4688_/Q sky130_fd_sc_hd__dfrtp_1
X_3708_ _4527_/Q _4636_/Q _4528_/Q _4637_/Q vssd1 vssd1 vccd1 vccd1 _3729_/C sky130_fd_sc_hd__a22oi_1
X_3639_ _3655_/S _4595_/Q vssd1 vssd1 vccd1 vccd1 _3639_/X sky130_fd_sc_hd__and2_1
XANTENNA__2401__S _2421_/S vssd1 vssd1 vccd1 vccd1 sky130_fd_sc_hd__diode_2
XFILLER_0_337 vccd1 vssd1 vccd1 vssd1 sky130_ef_sc_hd__decap_12
XFILLER_75_105 vssd1 vssd1 vccd1 vccd1 sky130_fd_sc_hd__decap_6
XFILLER_84_15 vccd1 vssd1 vccd1 vssd1 sky130_ef_sc_hd__decap_12
XFILLER_16_205 vssd1 vssd1 vccd1 vccd1 sky130_fd_sc_hd__decap_6
XANTENNA__2310__A1 _2310_/A1 vssd1 vssd1 vccd1 vccd1 sky130_fd_sc_hd__diode_2
XFILLER_17_53 vssd1 vssd1 vccd1 vccd1 sky130_fd_sc_hd__decap_3
XANTENNA__4274__D _4274_/D vssd1 vssd1 vccd1 vccd1 sky130_fd_sc_hd__diode_2
XFILLER_17_97 vccd1 vssd1 vccd1 vssd1 sky130_ef_sc_hd__decap_12
XANTENNA__4063__A1 _4083_/A1 vssd1 vssd1 vccd1 vccd1 sky130_fd_sc_hd__diode_2
XFILLER_31_208 vssd1 vssd1 vccd1 vccd1 sky130_fd_sc_hd__fill_2
XFILLER_71_399 vccd1 vssd1 vccd1 vssd1 sky130_ef_sc_hd__decap_12
XFILLER_12_433 vccd1 vssd1 vccd1 vssd1 sky130_ef_sc_hd__decap_12
XANTENNA__4063__S _4063_/S vssd1 vssd1 vccd1 vccd1 sky130_fd_sc_hd__diode_2
XFILLER_33_41 vssd1 vssd1 vccd1 vccd1 sky130_fd_sc_hd__fill_1
XFILLER_12_477 vssd1 vssd1 vccd1 vccd1 sky130_fd_sc_hd__fill_2
Xhold4 hold4/A vssd1 vssd1 vccd1 vccd1 hold4/X sky130_fd_sc_hd__dlygate4sd3_1
XFILLER_62_355 vssd1 vssd1 vccd1 vccd1 sky130_fd_sc_hd__fill_1
X_3990_ _4119_/S _4022_/A2 _4058_/B2 vssd1 vssd1 vccd1 vccd1 _3990_/Y sky130_fd_sc_hd__o21ai_1
X_2941_ _2940_/A _2940_/B _2940_/C vssd1 vssd1 vccd1 vccd1 _2942_/B sky130_fd_sc_hd__o21a_1
XFILLER_15_271 vssd1 vssd1 vccd1 vccd1 sky130_fd_sc_hd__decap_3
XTAP_TAPCELL_ROW_45_597 vssd1 vccd1 sky130_fd_sc_hd__tapvpwrvgnd_1
X_4611_ _4612_/CLK _4611_/D fanout429/X vssd1 vssd1 vccd1 vccd1 _4611_/Q sky130_fd_sc_hd__dfrtp_1
X_2872_ _2872_/A _2872_/B _2872_/C vssd1 vssd1 vccd1 vccd1 _2872_/Y sky130_fd_sc_hd__nand3_1
X_4542_ _4549_/CLK _4542_/D fanout415/X vssd1 vssd1 vccd1 vccd1 _4542_/Q sky130_fd_sc_hd__dfrtp_1
XANTENNA__4109__A2 _4361_/B1 vssd1 vssd1 vccd1 vccd1 sky130_fd_sc_hd__diode_2
X_4473_ _4546_/CLK _4473_/D fanout417/X vssd1 vssd1 vccd1 vccd1 hold23/A sky130_fd_sc_hd__dfrtp_1
X_3424_ _4598_/Q _3424_/A2 _3162_/B _3923_/A vssd1 vssd1 vccd1 vccd1 _3424_/X sky130_fd_sc_hd__o211a_1
X_3355_ _3383_/A1 _3354_/X _3383_/B1 vssd1 vssd1 vccd1 vccd1 _3355_/X sky130_fd_sc_hd__a21o_1
X_2306_ _3875_/A0 _2310_/A1 _4071_/S vssd1 vssd1 vccd1 vccd1 _2306_/X sky130_fd_sc_hd__mux2_1
X_3286_ _3286_/A _3286_/B _3286_/C _3286_/D vssd1 vssd1 vccd1 vccd1 _3286_/Y sky130_fd_sc_hd__nor4_1
X_2237_ hold25/X _4545_/Q _2242_/S vssd1 vssd1 vccd1 vccd1 _4416_/D sky130_fd_sc_hd__mux2_1
XANTENNA_fanout182_A _4167_/A0 vssd1 vssd1 vccd1 vccd1 sky130_fd_sc_hd__diode_2
XFILLER_38_396 vssd1 vssd1 vccd1 vccd1 sky130_fd_sc_hd__decap_8
XFILLER_80_141 vssd1 vssd1 vccd1 vccd1 sky130_fd_sc_hd__decap_6
XTAP_TAPCELL_ROW_0_178 vssd1 vccd1 sky130_fd_sc_hd__tapvpwrvgnd_1
XFILLER_80_185 vssd1 vssd1 vccd1 vccd1 sky130_fd_sc_hd__decap_3
XTAP_TAPCELL_ROW_0_189 vssd1 vccd1 sky130_fd_sc_hd__tapvpwrvgnd_1
X_4809_ clkload3/A _4809_/D fanout375/X vssd1 vssd1 vccd1 vccd1 _4809_/Q sky130_fd_sc_hd__dfrtp_1
XPHY_EDGE_ROW_17_Right_17 vssd1 vssd1 vccd1 vccd1 sky130_fd_sc_hd__decap_3
XFILLER_79_37 vccd1 vssd1 vccd1 vssd1 sky130_ef_sc_hd__decap_12
XFILLER_76_425 vccd1 vssd1 vccd1 vssd1 sky130_ef_sc_hd__decap_12
XFILLER_76_403 vssd1 vssd1 vccd1 vccd1 sky130_fd_sc_hd__fill_1
XPHY_EDGE_ROW_26_Right_26 vssd1 vssd1 vccd1 vccd1 sky130_fd_sc_hd__decap_3
XTAP_TAPCELL_ROW_87_976 vssd1 vccd1 sky130_fd_sc_hd__tapvpwrvgnd_1
XFILLER_29_341 vssd1 vssd1 vccd1 vccd1 sky130_fd_sc_hd__decap_4
XFILLER_28_85 vssd1 vssd1 vccd1 vccd1 sky130_fd_sc_hd__fill_1
XFILLER_29_385 vssd1 vssd1 vccd1 vccd1 sky130_fd_sc_hd__fill_1
XFILLER_44_300 vssd1 vssd1 vccd1 vccd1 sky130_fd_sc_hd__decap_8
XFILLER_44_355 vssd1 vssd1 vccd1 vccd1 sky130_fd_sc_hd__decap_8
XTAP_TAPCELL_ROW_70_821 vssd1 vccd1 sky130_fd_sc_hd__tapvpwrvgnd_1
XFILLER_71_196 vssd1 vssd1 vccd1 vccd1 sky130_fd_sc_hd__decap_3
XANTENNA__2306__S _4071_/S vssd1 vssd1 vccd1 vccd1 sky130_fd_sc_hd__diode_2
XPHY_EDGE_ROW_35_Right_35 vssd1 vssd1 vccd1 vccd1 sky130_fd_sc_hd__decap_3
XTAP_TAPCELL_ROW_42_567 vssd1 vccd1 sky130_fd_sc_hd__tapvpwrvgnd_1
XFILLER_60_83 vssd1 vssd1 vccd1 vccd1 sky130_fd_sc_hd__fill_1
XFILLER_4_473 vssd1 vssd1 vccd1 vccd1 sky130_fd_sc_hd__decap_3
XPHY_EDGE_ROW_44_Right_44 vssd1 vssd1 vccd1 vccd1 sky130_fd_sc_hd__decap_3
X_3140_ _3134_/A _3133_/A _3133_/B _3135_/A _3135_/B vssd1 vssd1 vccd1 vccd1 _3147_/A
+ sky130_fd_sc_hd__o32a_1
XFILLER_82_417 vssd1 vssd1 vccd1 vccd1 sky130_fd_sc_hd__decap_3
XFILLER_82_406 vssd1 vssd1 vccd1 vccd1 sky130_fd_sc_hd__fill_1
X_3071_ _4534_/Q _3157_/A2 _3054_/Y _3070_/Y vssd1 vssd1 vccd1 vccd1 _4534_/D sky130_fd_sc_hd__o22a_1
XANTENNA__2277__A _4001_/C vssd1 vssd1 vccd1 vccd1 sky130_fd_sc_hd__diode_2
XANTENNA__4195__C _4323_/S vssd1 vssd1 vccd1 vccd1 sky130_fd_sc_hd__diode_2
XANTENNA__4275__A1 _4274_/D vssd1 vssd1 vccd1 vccd1 sky130_fd_sc_hd__diode_2
X_3973_ _4684_/Q _3983_/B2 _3971_/X _3972_/Y vssd1 vssd1 vccd1 vccd1 _4684_/D sky130_fd_sc_hd__o22a_1
XPHY_EDGE_ROW_53_Right_53 vssd1 vssd1 vccd1 vccd1 sky130_fd_sc_hd__decap_3
X_2924_ _2918_/X _2924_/B _2924_/C vssd1 vssd1 vccd1 vccd1 _2924_/X sky130_fd_sc_hd__and3b_1
X_2855_ _2802_/C _2806_/A _2804_/Y vssd1 vssd1 vccd1 vccd1 _2857_/C sky130_fd_sc_hd__a21o_1
XANTENNA__3555__B _3613_/B vssd1 vssd1 vccd1 vccd1 sky130_fd_sc_hd__diode_2
Xhold201 _4700_/Q vssd1 vssd1 vccd1 vccd1 hold201/X sky130_fd_sc_hd__dlygate4sd3_1
X_4525_ _4635_/CLK _4525_/D fanout411/X vssd1 vssd1 vccd1 vccd1 _4525_/Q sky130_fd_sc_hd__dfrtp_1
X_2786_ _4758_/Q _4773_/Q _2786_/C vssd1 vssd1 vccd1 vccd1 _2786_/X sky130_fd_sc_hd__and3_1
Xhold223 _4620_/Q vssd1 vssd1 vccd1 vccd1 hold223/X sky130_fd_sc_hd__dlygate4sd3_1
Xhold212 _4755_/Q vssd1 vssd1 vccd1 vccd1 hold212/X sky130_fd_sc_hd__dlygate4sd3_1
XPHY_EDGE_ROW_62_Right_62 vssd1 vssd1 vccd1 vccd1 sky130_fd_sc_hd__decap_3
X_4456_ _4806_/CLK _4456_/D fanout385/X vssd1 vssd1 vccd1 vccd1 _4456_/Q sky130_fd_sc_hd__dfrtp_1
X_4387_ _4215_/C input33/X _4408_/S vssd1 vssd1 vccd1 vccd1 _4796_/D sky130_fd_sc_hd__mux2_1
X_3407_ _3423_/A1 _3404_/Y _3406_/X _3423_/B1 vssd1 vssd1 vccd1 vccd1 _3407_/X sky130_fd_sc_hd__a31o_1
XANTENNA_fanout397_A fanout398/X vssd1 vssd1 vccd1 vccd1 sky130_fd_sc_hd__diode_2
X_3338_ _3338_/A _3338_/B _4541_/Q _4582_/Q vssd1 vssd1 vccd1 vccd1 _3338_/X sky130_fd_sc_hd__or4bb_1
XTAP_TAPCELL_ROW_5_237 vssd1 vccd1 sky130_fd_sc_hd__tapvpwrvgnd_1
X_3269_ _4545_/Q _4586_/Q vssd1 vssd1 vccd1 vccd1 _3354_/B sky130_fd_sc_hd__xnor2_2
XANTENNA_fanout185_X _4099_/A0 vssd1 vssd1 vccd1 vccd1 sky130_fd_sc_hd__diode_2
XTAP_TAPCELL_ROW_84_946 vssd1 vccd1 sky130_fd_sc_hd__tapvpwrvgnd_1
XFILLER_73_439 vssd1 vssd1 vccd1 vccd1 sky130_fd_sc_hd__decap_8
XPHY_EDGE_ROW_71_Right_71 vssd1 vssd1 vccd1 vccd1 sky130_fd_sc_hd__decap_3
XANTENNA_clkbuf_leaf_10_clk_A clkload1/A vssd1 vssd1 vccd1 vccd1 sky130_fd_sc_hd__diode_2
XPHY_EDGE_ROW_80_Right_80 vssd1 vssd1 vccd1 vccd1 sky130_fd_sc_hd__decap_3
XANTENNA_fanout98_X _3741_/S vssd1 vssd1 vccd1 vccd1 sky130_fd_sc_hd__diode_2
XANTENNA_clkbuf_leaf_25_clk_A clkbuf_2_3__f_clk/X vssd1 vssd1 vccd1 vccd1 sky130_fd_sc_hd__diode_2
XFILLER_76_277 vccd1 vssd1 vccd1 vssd1 sky130_ef_sc_hd__decap_12
XFILLER_64_417 vssd1 vssd1 vccd1 vccd1 sky130_fd_sc_hd__decap_3
XFILLER_64_439 vccd1 vssd1 vccd1 vssd1 sky130_ef_sc_hd__decap_12
XTAP_TAPCELL_ROW_47_615 vssd1 vccd1 sky130_fd_sc_hd__tapvpwrvgnd_1
XFILLER_44_141 vssd1 vssd1 vccd1 vccd1 sky130_fd_sc_hd__decap_8
XANTENNA__4813__Q _4813_/Q vssd1 vssd1 vccd1 vccd1 sky130_fd_sc_hd__diode_2
XFILLER_17_399 vssd1 vssd1 vccd1 vccd1 sky130_fd_sc_hd__decap_8
XFILLER_32_336 vssd1 vssd1 vccd1 vccd1 sky130_fd_sc_hd__decap_6
XTAP_TAPCELL_ROW_55_681 vssd1 vccd1 sky130_fd_sc_hd__tapvpwrvgnd_1
X_2640_ _2688_/B _2640_/B vssd1 vssd1 vccd1 vccd1 _2641_/B sky130_fd_sc_hd__nand2_1
XTAP_TAPCELL_ROW_10_283 vssd1 vccd1 sky130_fd_sc_hd__tapvpwrvgnd_1
X_2571_ _2571_/A _2571_/B hold79/A vssd1 vssd1 vccd1 vccd1 _2617_/B sky130_fd_sc_hd__or3b_2
X_4310_ _4238_/S _3919_/B _4361_/B1 vssd1 vssd1 vccd1 vccd1 _4310_/Y sky130_fd_sc_hd__a21oi_1
X_4241_ _4240_/Y _4239_/X _4238_/X hold182/X _4241_/B2 vssd1 vssd1 vccd1 vccd1 _4752_/D
+ sky130_fd_sc_hd__o32a_1
X_4172_ _4223_/D _4172_/B _4175_/C _4372_/A vssd1 vssd1 vccd1 vccd1 _4172_/X sky130_fd_sc_hd__and4b_1
X_3123_ _3144_/A _3123_/B vssd1 vssd1 vccd1 vccd1 _3124_/B sky130_fd_sc_hd__xnor2_1
XANTENNA__4248__A1 _4754_/Q vssd1 vssd1 vccd1 vccd1 sky130_fd_sc_hd__diode_2
XTAP_TAPCELL_ROW_2_207 vssd1 vccd1 sky130_fd_sc_hd__tapvpwrvgnd_1
X_3054_ _3055_/A _3055_/B _3055_/C vssd1 vssd1 vccd1 vccd1 _3054_/Y sky130_fd_sc_hd__a21oi_1
XTAP_TAPCELL_ROW_81_916 vssd1 vccd1 sky130_fd_sc_hd__tapvpwrvgnd_1
XFILLER_63_461 vssd1 vssd1 vccd1 vccd1 sky130_fd_sc_hd__decap_4
XTAP_TAPCELL_ROW_18_350 vssd1 vccd1 sky130_fd_sc_hd__tapvpwrvgnd_1
X_3956_ _3873_/Y _4021_/D _4017_/D _3899_/Y vssd1 vssd1 vccd1 vccd1 _3956_/Y sky130_fd_sc_hd__o22ai_1
XANTENNA_fanout145_A _3922_/B1 vssd1 vssd1 vccd1 vccd1 sky130_fd_sc_hd__diode_2
X_2907_ _2907_/A _2907_/B vssd1 vssd1 vccd1 vccd1 _2914_/A sky130_fd_sc_hd__nor2_1
XFILLER_31_380 vssd1 vssd1 vccd1 vccd1 sky130_fd_sc_hd__decap_6
XFILLER_50_177 vssd1 vssd1 vccd1 vccd1 sky130_fd_sc_hd__fill_1
X_3887_ _4231_/D _4239_/B vssd1 vssd1 vccd1 vccd1 _4179_/B sky130_fd_sc_hd__or2_1
XANTENNA_fanout312_A _4798_/Q vssd1 vssd1 vccd1 vccd1 sky130_fd_sc_hd__diode_2
X_2838_ _4761_/Q _4776_/Q vssd1 vssd1 vccd1 vccd1 _2838_/Y sky130_fd_sc_hd__nand2_1
X_2769_ _2770_/A _4699_/Q vssd1 vssd1 vccd1 vccd1 _2769_/Y sky130_fd_sc_hd__nand2_1
XANTENNA_fanout100_X _3549_/A vssd1 vssd1 vccd1 vccd1 sky130_fd_sc_hd__diode_2
X_4508_ _4579_/CLK _4508_/D fanout432/X vssd1 vssd1 vccd1 vccd1 hold91/A sky130_fd_sc_hd__dfrtp_1
X_4439_ _4580_/CLK _4439_/D fanout436/X vssd1 vssd1 vccd1 vccd1 hold62/A sky130_fd_sc_hd__dfrtp_1
XFILLER_76_27 vssd1 vssd1 vccd1 vccd1 sky130_fd_sc_hd__fill_1
XFILLER_58_200 vssd1 vssd1 vccd1 vccd1 sky130_fd_sc_hd__fill_2
XFILLER_58_211 vssd1 vssd1 vccd1 vccd1 sky130_fd_sc_hd__fill_1
XFILLER_73_225 vccd1 vssd1 vccd1 vssd1 sky130_ef_sc_hd__decap_12
XFILLER_18_119 vssd1 vssd1 vccd1 vccd1 sky130_fd_sc_hd__decap_8
XFILLER_26_174 vssd1 vssd1 vccd1 vccd1 sky130_fd_sc_hd__decap_6
XFILLER_41_166 vssd1 vssd1 vccd1 vccd1 sky130_fd_sc_hd__fill_2
XFILLER_41_188 vssd1 vssd1 vccd1 vccd1 sky130_fd_sc_hd__fill_2
XFILLER_22_391 vssd1 vssd1 vccd1 vccd1 sky130_fd_sc_hd__fill_1
XANTENNA__4071__S _4071_/S vssd1 vssd1 vccd1 vccd1 sky130_fd_sc_hd__diode_2
XFILLER_41_85 vssd1 vssd1 vccd1 vccd1 sky130_fd_sc_hd__fill_2
XANTENNA__3922__B1 _3922_/B1 vssd1 vssd1 vccd1 vccd1 sky130_fd_sc_hd__diode_2
XANTENNA__4808__Q _4808_/Q vssd1 vssd1 vccd1 vccd1 sky130_fd_sc_hd__diode_2
XFILLER_37_417 vccd1 vssd1 vccd1 vssd1 sky130_ef_sc_hd__decap_12
XFILLER_17_152 vssd1 vssd1 vccd1 vccd1 sky130_fd_sc_hd__decap_3
XANTENNA__2274__B _2274_/B vssd1 vssd1 vccd1 vccd1 sky130_fd_sc_hd__diode_2
XTAP_TAPCELL_ROW_15_320 vssd1 vccd1 sky130_fd_sc_hd__tapvpwrvgnd_1
X_3810_ hold133/X _3828_/A2 _2490_/X _3809_/Y vssd1 vssd1 vccd1 vccd1 _4623_/D sky130_fd_sc_hd__a22o_1
X_4790_ _4794_/CLK _4790_/D fanout375/X vssd1 vssd1 vccd1 vccd1 _4790_/Q sky130_fd_sc_hd__dfrtp_1
XFILLER_32_155 vccd1 vssd1 vccd1 vssd1 sky130_ef_sc_hd__decap_12
XFILLER_60_442 vssd1 vssd1 vccd1 vccd1 sky130_fd_sc_hd__decap_3
X_3741_ _3740_/Y hold210/X _3741_/S vssd1 vssd1 vccd1 vccd1 _4607_/D sky130_fd_sc_hd__mux2_1
XFILLER_60_475 vssd1 vssd1 vccd1 vccd1 sky130_fd_sc_hd__fill_1
XFILLER_13_391 vssd1 vssd1 vccd1 vccd1 sky130_fd_sc_hd__fill_1
X_3672_ _4525_/Q _4634_/Q vssd1 vssd1 vccd1 vccd1 _3674_/A sky130_fd_sc_hd__and2_1
X_2623_ _2623_/A _2623_/B vssd1 vssd1 vccd1 vccd1 _2623_/Y sky130_fd_sc_hd__xnor2_2
X_2554_ _2554_/A _2554_/B vssd1 vssd1 vccd1 vccd1 _3815_/A sky130_fd_sc_hd__xnor2_1
X_2485_ _2465_/A _2465_/B _2468_/A vssd1 vssd1 vccd1 vccd1 _2487_/B sky130_fd_sc_hd__o21ai_1
X_4224_ _4223_/C _4240_/A2 _4224_/B1 vssd1 vssd1 vccd1 vccd1 _4224_/Y sky130_fd_sc_hd__o21ai_1
X_4155_ _4171_/A0 _4167_/A1 _4227_/C vssd1 vssd1 vccd1 vccd1 _4155_/X sky130_fd_sc_hd__mux2_1
X_3106_ _3150_/A _4784_/Q _4769_/Q vssd1 vssd1 vccd1 vccd1 _3106_/X sky130_fd_sc_hd__and3_1
XFILLER_28_428 vccd1 vssd1 vccd1 vssd1 sky130_ef_sc_hd__decap_12
XFILLER_55_225 vccd1 vssd1 vccd1 vssd1 sky130_ef_sc_hd__decap_12
XANTENNA__3429__C1 _4377_/C1 vssd1 vssd1 vccd1 vccd1 sky130_fd_sc_hd__diode_2
X_4086_ _4085_/Y _4084_/X _4083_/X _4713_/Q _4205_/B2 vssd1 vssd1 vccd1 vccd1 _4713_/D
+ sky130_fd_sc_hd__o32a_1
X_3037_ _3037_/A _3037_/B vssd1 vssd1 vccd1 vccd1 _3055_/A sky130_fd_sc_hd__nand2_1
XFILLER_70_206 vssd1 vssd1 vccd1 vccd1 sky130_fd_sc_hd__fill_2
XTAP_TAPCELL_ROW_66_787 vssd1 vccd1 sky130_fd_sc_hd__tapvpwrvgnd_1
XANTENNA__3444__A2 _3504_/A2 vssd1 vssd1 vccd1 vccd1 sky130_fd_sc_hd__diode_2
XFILLER_55_269 vssd1 vssd1 vccd1 vccd1 sky130_fd_sc_hd__decap_8
XFILLER_11_328 vssd1 vssd1 vccd1 vccd1 sky130_fd_sc_hd__decap_8
XFILLER_51_497 vssd1 vssd1 vccd1 vccd1 sky130_fd_sc_hd__fill_2
X_3939_ _3935_/S _3900_/X _3900_/B _4673_/Q vssd1 vssd1 vccd1 vccd1 _3939_/X sky130_fd_sc_hd__a2bb2o_1
XANTENNA__2404__S _2420_/S vssd1 vssd1 vccd1 vccd1 sky130_fd_sc_hd__diode_2
XTAP_TAPCELL_ROW_21_378 vssd1 vccd1 sky130_fd_sc_hd__tapvpwrvgnd_1
XFILLER_3_505 vccd1 vssd1 vccd1 vssd1 sky130_ef_sc_hd__decap_12
XFILLER_87_15 vccd1 vssd1 vccd1 vssd1 sky130_ef_sc_hd__decap_12
XFILLER_2_6 vssd1 vssd1 vccd1 vccd1 sky130_fd_sc_hd__fill_1
Xfanout330 _4793_/Q vssd1 vssd1 vccd1 vccd1 _2304_/A1 sky130_fd_sc_hd__buf_2
Xfanout341 _4790_/Q vssd1 vssd1 vccd1 vccd1 _4253_/S sky130_fd_sc_hd__buf_2
Xfanout363 _3541_/B1 vssd1 vssd1 vccd1 vccd1 _3395_/B1 sky130_fd_sc_hd__buf_2
Xfanout374 hold87/A vssd1 vssd1 vccd1 vccd1 _3282_/A sky130_fd_sc_hd__buf_2
Xfanout352 _4685_/Q vssd1 vssd1 vccd1 vccd1 _2770_/A sky130_fd_sc_hd__clkbuf_2
Xfanout396 fanout398/X vssd1 vssd1 vccd1 vccd1 fanout396/X sky130_fd_sc_hd__clkbuf_4
Xfanout385 fanout388/X vssd1 vssd1 vccd1 vccd1 fanout385/X sky130_fd_sc_hd__clkbuf_4
XFILLER_34_409 vssd1 vssd1 vccd1 vccd1 sky130_fd_sc_hd__fill_1
XFILLER_36_85 vssd1 vssd1 vccd1 vccd1 sky130_fd_sc_hd__fill_2
XFILLER_42_442 vssd1 vssd1 vccd1 vccd1 sky130_fd_sc_hd__decap_8
XTAP_TAPCELL_ROW_12_301 vssd1 vccd1 sky130_fd_sc_hd__tapvpwrvgnd_1
XFILLER_14_199 vssd1 vssd1 vccd1 vccd1 sky130_fd_sc_hd__decap_4
Xinput27 s_axis_tdata[31] vssd1 vssd1 vccd1 vccd1 input27/X sky130_fd_sc_hd__clkbuf_1
Xinput16 s_axis_tdata[21] vssd1 vssd1 vccd1 vccd1 input16/X sky130_fd_sc_hd__clkbuf_1
XFILLER_6_376 vssd1 vssd1 vccd1 vccd1 sky130_fd_sc_hd__fill_1
XFILLER_6_365 vssd1 vssd1 vccd1 vccd1 sky130_fd_sc_hd__decap_4
XFILLER_69_328 vssd1 vssd1 vccd1 vccd1 sky130_fd_sc_hd__fill_1
X_2270_ hold39/X _4578_/Q _2270_/S vssd1 vssd1 vccd1 vccd1 _4449_/D sky130_fd_sc_hd__mux2_1
XANTENNA__4187__D _4789_/Q vssd1 vssd1 vccd1 vccd1 sky130_fd_sc_hd__diode_2
XFILLER_37_225 vssd1 vssd1 vccd1 vccd1 sky130_fd_sc_hd__decap_4
XFILLER_18_461 vccd1 vssd1 vccd1 vssd1 sky130_ef_sc_hd__decap_12
XFILLER_52_239 vssd1 vssd1 vccd1 vccd1 sky130_fd_sc_hd__fill_1
XTAP_TAPCELL_ROW_63_757 vssd1 vccd1 sky130_fd_sc_hd__tapvpwrvgnd_1
XFILLER_33_431 vccd1 vssd1 vccd1 vssd1 sky130_ef_sc_hd__decap_12
XANTENNA__4387__A0 _4215_/C vssd1 vssd1 vccd1 vccd1 sky130_fd_sc_hd__diode_2
XFILLER_60_261 vssd1 vssd1 vccd1 vccd1 sky130_fd_sc_hd__fill_2
X_4773_ _4774_/CLK _4773_/D fanout401/X vssd1 vssd1 vccd1 vccd1 _4773_/Q sky130_fd_sc_hd__dfrtp_1
X_3724_ _3743_/A _3743_/B vssd1 vssd1 vccd1 vccd1 _3734_/A sky130_fd_sc_hd__or2_1
XFILLER_20_169 vssd1 vssd1 vccd1 vccd1 sky130_fd_sc_hd__fill_1
X_3655_ _3654_/Y hold222/X _3655_/S vssd1 vssd1 vccd1 vccd1 _4597_/D sky130_fd_sc_hd__mux2_1
XANTENNA__4139__A0 _4171_/A0 vssd1 vssd1 vccd1 vccd1 sky130_fd_sc_hd__diode_2
X_2606_ _2604_/Y _2606_/B vssd1 vssd1 vccd1 vccd1 _2610_/A sky130_fd_sc_hd__and2b_1
X_3586_ _4514_/Q _4623_/Q vssd1 vssd1 vccd1 vccd1 _3587_/B sky130_fd_sc_hd__nor2_1
X_2537_ _4737_/Q _4707_/Q vssd1 vssd1 vccd1 vccd1 _2537_/X sky130_fd_sc_hd__and2_1
XFILLER_87_125 vssd1 vssd1 vccd1 vccd1 sky130_fd_sc_hd__fill_2
X_2468_ _2468_/A _2468_/B vssd1 vssd1 vccd1 vccd1 _2473_/B sky130_fd_sc_hd__nand2_1
XFILLER_87_169 vccd1 vssd1 vccd1 vssd1 sky130_ef_sc_hd__decap_12
X_4207_ _4258_/C _4211_/B _4340_/A _4239_/D vssd1 vssd1 vccd1 vccd1 _4207_/X sky130_fd_sc_hd__and4b_1
X_2399_ _4567_/Q hold19/A _2425_/S vssd1 vssd1 vccd1 vccd1 _2399_/X sky130_fd_sc_hd__mux2_1
X_4138_ _4135_/X _4136_/X _4137_/Y _4138_/B1 hold174/X vssd1 vssd1 vccd1 vccd1 _4726_/D
+ sky130_fd_sc_hd__o32a_1
X_4069_ _4203_/C _4105_/A2 _4130_/B1 vssd1 vssd1 vccd1 vccd1 _4069_/Y sky130_fd_sc_hd__o21ai_1
XFILLER_83_386 vssd1 vssd1 vccd1 vccd1 sky130_fd_sc_hd__decap_6
XTAP_TAPCELL_ROW_26_426 vssd1 vccd1 sky130_fd_sc_hd__tapvpwrvgnd_1
XFILLER_11_147 vssd1 vssd1 vccd1 vccd1 sky130_fd_sc_hd__decap_8
XFILLER_11_125 vssd1 vssd1 vccd1 vccd1 sky130_fd_sc_hd__decap_6
XTAP_TAPCELL_ROW_34_492 vssd1 vccd1 sky130_fd_sc_hd__tapvpwrvgnd_1
XFILLER_11_169 vssd1 vssd1 vccd1 vccd1 sky130_fd_sc_hd__decap_6
XFILLER_22_43 vssd1 vssd1 vccd1 vccd1 sky130_fd_sc_hd__fill_1
XFILLER_3_335 vssd1 vssd1 vccd1 vccd1 sky130_fd_sc_hd__fill_1
XFILLER_0_3 vccd1 vssd1 vccd1 vssd1 sky130_ef_sc_hd__decap_12
XFILLER_3_357 vccd1 vssd1 vccd1 vssd1 sky130_ef_sc_hd__decap_12
XANTENNA_fanout80_X _3423_/A1 vssd1 vssd1 vccd1 vccd1 sky130_fd_sc_hd__diode_2
Xfanout160 _4338_/A2 vssd1 vssd1 vccd1 vccd1 _4241_/B2 sky130_fd_sc_hd__buf_1
Xfanout171 _4044_/X vssd1 vssd1 vccd1 vccd1 _4103_/A1 sky130_fd_sc_hd__clkbuf_2
Xfanout182 _4167_/A0 vssd1 vssd1 vccd1 vccd1 _4171_/A0 sky130_fd_sc_hd__clkbuf_2
Xfanout193 _2872_/Y vssd1 vssd1 vccd1 vccd1 _3862_/B sky130_fd_sc_hd__clkbuf_2
XFILLER_19_225 vssd1 vssd1 vccd1 vccd1 sky130_fd_sc_hd__decap_4
XFILLER_63_50 vssd1 vssd1 vccd1 vccd1 sky130_fd_sc_hd__fill_1
XANTENNA__4081__A2 _4081_/A2 vssd1 vssd1 vccd1 vccd1 sky130_fd_sc_hd__diode_2
XTAP_TAPCELL_ROW_60_727 vssd1 vccd1 sky130_fd_sc_hd__tapvpwrvgnd_1
XFILLER_10_191 vssd1 vssd1 vccd1 vccd1 sky130_fd_sc_hd__decap_4
XFILLER_6_195 vssd1 vssd1 vccd1 vccd1 sky130_fd_sc_hd__fill_1
X_3440_ _4560_/Q _3540_/B2 _3438_/X _3439_/X vssd1 vssd1 vccd1 vccd1 _4560_/D sky130_fd_sc_hd__a22o_1
X_3371_ _3371_/A _3371_/B vssd1 vssd1 vccd1 vccd1 _3371_/X sky130_fd_sc_hd__or2_1
X_2322_ _2341_/A0 _2341_/A1 _4087_/S vssd1 vssd1 vccd1 vccd1 _2322_/X sky130_fd_sc_hd__mux2_1
XTAP_TAPCELL_ROW_68_805 vssd1 vccd1 sky130_fd_sc_hd__tapvpwrvgnd_1
XFILLER_69_169 vssd1 vssd1 vccd1 vccd1 sky130_fd_sc_hd__decap_8
X_2253_ hold72/X _4561_/Q _2272_/S vssd1 vssd1 vccd1 vccd1 _4432_/D sky130_fd_sc_hd__mux2_1
XFILLER_80_301 vssd1 vssd1 vccd1 vccd1 sky130_fd_sc_hd__decap_6
XTAP_TAPCELL_ROW_76_871 vssd1 vccd1 sky130_fd_sc_hd__tapvpwrvgnd_1
XFILLER_80_334 vccd1 vssd1 vccd1 vssd1 sky130_ef_sc_hd__decap_12
XFILLER_40_209 vccd1 vssd1 vccd1 vssd1 sky130_ef_sc_hd__decap_12
XFILLER_21_445 vssd1 vssd1 vccd1 vccd1 sky130_fd_sc_hd__fill_1
X_4756_ _4771_/CLK _4756_/D fanout391/X vssd1 vssd1 vccd1 vccd1 _4756_/Q sky130_fd_sc_hd__dfrtp_1
X_4687_ _4687_/CLK _4687_/D fanout384/X vssd1 vssd1 vccd1 vccd1 _4687_/Q sky130_fd_sc_hd__dfrtp_1
X_3707_ _3729_/B vssd1 vssd1 vccd1 vccd1 _3707_/Y sky130_fd_sc_hd__inv_2
X_3638_ _3621_/Y _3632_/X _3643_/A _3643_/B vssd1 vssd1 vccd1 vccd1 _3638_/X sky130_fd_sc_hd__a211o_1
X_3569_ _3561_/A _3564_/X _3566_/Y _3568_/X _3549_/A vssd1 vssd1 vccd1 vccd1 _3569_/X
+ sky130_fd_sc_hd__o311a_1
XFILLER_0_305 vssd1 vssd1 vccd1 vccd1 sky130_fd_sc_hd__decap_3
XFILLER_0_349 vccd1 vssd1 vccd1 vssd1 sky130_ef_sc_hd__decap_12
XANTENNA_fanout382_X fanout382/X vssd1 vssd1 vccd1 vccd1 sky130_fd_sc_hd__diode_2
XFILLER_48_309 vccd1 vssd1 vccd1 vssd1 sky130_ef_sc_hd__decap_12
XFILLER_84_27 vssd1 vssd1 vccd1 vccd1 sky130_fd_sc_hd__fill_1
XTAP_TAPCELL_ROW_39_540 vssd1 vccd1 sky130_fd_sc_hd__tapvpwrvgnd_1
XFILLER_56_342 vssd1 vssd1 vccd1 vccd1 sky130_fd_sc_hd__fill_2
XFILLER_71_334 vssd1 vssd1 vccd1 vccd1 sky130_fd_sc_hd__fill_2
XFILLER_24_250 vssd1 vssd1 vccd1 vccd1 sky130_fd_sc_hd__fill_2
XFILLER_12_445 vccd1 vssd1 vccd1 vssd1 sky130_ef_sc_hd__decap_12
XANTENNA__3810__A2 _3828_/A2 vssd1 vssd1 vccd1 vccd1 sky130_fd_sc_hd__diode_2
XFILLER_8_449 vccd1 vssd1 vccd1 vssd1 sky130_ef_sc_hd__decap_12
XFILLER_79_401 vssd1 vssd1 vccd1 vccd1 sky130_fd_sc_hd__fill_2
XFILLER_58_83 vssd1 vssd1 vccd1 vccd1 sky130_fd_sc_hd__fill_1
Xhold5 hold5/A vssd1 vssd1 vccd1 vccd1 hold5/X sky130_fd_sc_hd__dlygate4sd3_1
XFILLER_62_301 vssd1 vssd1 vccd1 vccd1 sky130_fd_sc_hd__fill_1
X_2940_ _2940_/A _2940_/B _2940_/C vssd1 vssd1 vccd1 vccd1 _2942_/A sky130_fd_sc_hd__nor3_1
XANTENNA__4107__X _4107_/X vssd1 vssd1 vccd1 vccd1 sky130_fd_sc_hd__diode_2
X_2871_ _2868_/Y _4468_/Q _2871_/C vssd1 vssd1 vccd1 vccd1 _2871_/Y sky130_fd_sc_hd__nand3b_1
XTAP_TAPCELL_ROW_45_598 vssd1 vccd1 sky130_fd_sc_hd__tapvpwrvgnd_1
X_4610_ _4612_/CLK _4610_/D fanout429/X vssd1 vssd1 vccd1 vccd1 _4610_/Q sky130_fd_sc_hd__dfrtp_2
XFILLER_30_253 vssd1 vssd1 vccd1 vccd1 sky130_fd_sc_hd__fill_2
X_4541_ _4549_/CLK _4541_/D fanout416/X vssd1 vssd1 vccd1 vccd1 _4541_/Q sky130_fd_sc_hd__dfrtp_2
X_4472_ _4546_/CLK _4472_/D fanout418/X vssd1 vssd1 vccd1 vccd1 hold21/A sky130_fd_sc_hd__dfrtp_1
X_3423_ _3423_/A1 _3421_/Y _3422_/X _3423_/B1 vssd1 vssd1 vccd1 vccd1 _3423_/X sky130_fd_sc_hd__a31o_1
X_3354_ _3354_/A _3354_/B vssd1 vssd1 vccd1 vccd1 _3354_/X sky130_fd_sc_hd__xor2_1
XFILLER_85_404 vssd1 vssd1 vccd1 vccd1 sky130_fd_sc_hd__decap_6
X_2305_ hold167/X _3983_/B2 _2304_/X _2302_/X vssd1 vssd1 vccd1 vccd1 _4458_/D sky130_fd_sc_hd__o22a_1
X_3285_ _3286_/A _3286_/B _3286_/D vssd1 vssd1 vccd1 vccd1 _3285_/Y sky130_fd_sc_hd__nor3_1
X_2236_ hold45/X _4544_/Q _2242_/S vssd1 vssd1 vccd1 vccd1 _4415_/D sky130_fd_sc_hd__mux2_1
XFILLER_65_150 vssd1 vssd1 vccd1 vccd1 sky130_fd_sc_hd__decap_8
XTAP_TAPCELL_ROW_36_510 vssd1 vccd1 sky130_fd_sc_hd__tapvpwrvgnd_1
XANTENNA__4045__A2 _4083_/A1 vssd1 vssd1 vccd1 vccd1 sky130_fd_sc_hd__diode_2
XTAP_TAPCELL_ROW_0_179 vssd1 vccd1 sky130_fd_sc_hd__tapvpwrvgnd_1
XANTENNA_fanout342_A _4320_/A vssd1 vssd1 vccd1 vccd1 sky130_fd_sc_hd__diode_2
XFILLER_80_197 vssd1 vssd1 vccd1 vccd1 sky130_fd_sc_hd__fill_1
X_4808_ _4808_/CLK _4808_/D fanout377/X vssd1 vssd1 vccd1 vccd1 _4808_/Q sky130_fd_sc_hd__dfrtp_1
XANTENNA_fanout228_X _4105_/A2 vssd1 vssd1 vccd1 vccd1 sky130_fd_sc_hd__diode_2
X_4739_ clkload6/A _4739_/D fanout382/X vssd1 vssd1 vccd1 vccd1 _4739_/Q sky130_fd_sc_hd__dfrtp_1
XANTENNA__2412__S _2420_/S vssd1 vssd1 vccd1 vccd1 sky130_fd_sc_hd__diode_2
XFILLER_79_49 vssd1 vssd1 vccd1 vccd1 sky130_fd_sc_hd__decap_6
XTAP_TAPCELL_ROW_8_257 vssd1 vccd1 sky130_fd_sc_hd__tapvpwrvgnd_1
XFILLER_0_113 vccd1 vssd1 vccd1 vssd1 sky130_ef_sc_hd__decap_12
XFILLER_76_437 vssd1 vssd1 vccd1 vccd1 sky130_fd_sc_hd__fill_2
XTAP_TAPCELL_ROW_87_977 vssd1 vccd1 sky130_fd_sc_hd__tapvpwrvgnd_1
XFILLER_28_75 vssd1 vssd1 vccd1 vccd1 sky130_fd_sc_hd__fill_2
XTAP_TAPCELL_ROW_70_822 vssd1 vccd1 sky130_fd_sc_hd__tapvpwrvgnd_1
XFILLER_12_253 vccd1 vssd1 vccd1 vssd1 sky130_ef_sc_hd__decap_12
XTAP_TAPCELL_ROW_42_568 vssd1 vccd1 sky130_fd_sc_hd__tapvpwrvgnd_1
XANTENNA__2322__S _4087_/S vssd1 vssd1 vccd1 vccd1 sky130_fd_sc_hd__diode_2
XFILLER_5_57 vccd1 vssd1 vccd1 vssd1 sky130_ef_sc_hd__decap_12
XFILLER_79_264 vssd1 vssd1 vccd1 vccd1 sky130_fd_sc_hd__decap_3
XANTENNA__3947__A1_N _4071_/S vssd1 vssd1 vccd1 vccd1 sky130_fd_sc_hd__diode_2
XANTENNA__4249__S _4320_/A vssd1 vssd1 vccd1 vccd1 sky130_fd_sc_hd__diode_2
X_3070_ _3056_/Y _3069_/Y _3157_/A2 vssd1 vssd1 vccd1 vccd1 _3070_/Y sky130_fd_sc_hd__o21ai_1
XPHY_EDGE_ROW_19_Left_107 vssd1 vssd1 vccd1 vccd1 sky130_fd_sc_hd__decap_3
XANTENNA__4195__D _4199_/D vssd1 vssd1 vccd1 vccd1 sky130_fd_sc_hd__diode_2
XANTENNA__2286__A1 _2310_/A1 vssd1 vssd1 vccd1 vccd1 sky130_fd_sc_hd__diode_2
XFILLER_35_301 vssd1 vssd1 vccd1 vccd1 sky130_fd_sc_hd__fill_1
X_3972_ _4037_/D _3899_/Y _3983_/B2 vssd1 vssd1 vccd1 vccd1 _3972_/Y sky130_fd_sc_hd__o21ai_1
X_2923_ _2924_/B _2924_/C _2918_/X vssd1 vssd1 vccd1 vccd1 _2923_/Y sky130_fd_sc_hd__a21boi_1
XPHY_EDGE_ROW_28_Left_116 vssd1 vssd1 vccd1 vccd1 sky130_fd_sc_hd__decap_3
X_2854_ _2872_/A _2801_/Y _2804_/Y _2802_/C vssd1 vssd1 vccd1 vccd1 _2857_/B sky130_fd_sc_hd__o211ai_1
X_2785_ _2785_/A _2785_/B _2785_/C vssd1 vssd1 vccd1 vccd1 _2785_/X sky130_fd_sc_hd__and3_1
Xhold202 _4679_/Q vssd1 vssd1 vccd1 vccd1 hold202/X sky130_fd_sc_hd__dlygate4sd3_1
X_4524_ clkload9/A _4524_/D fanout411/X vssd1 vssd1 vccd1 vccd1 _4524_/Q sky130_fd_sc_hd__dfrtp_1
Xhold224 _4660_/Q vssd1 vssd1 vccd1 vccd1 hold224/X sky130_fd_sc_hd__dlygate4sd3_1
Xhold213 _4759_/Q vssd1 vssd1 vccd1 vccd1 hold213/X sky130_fd_sc_hd__dlygate4sd3_1
X_4455_ _4686_/CLK _4455_/D fanout384/X vssd1 vssd1 vccd1 vccd1 _4455_/Q sky130_fd_sc_hd__dfrtp_1
X_4386_ _4071_/S input32/X _4402_/S vssd1 vssd1 vccd1 vccd1 _4795_/D sky130_fd_sc_hd__mux2_1
X_3406_ _3406_/A _3406_/B _3406_/C vssd1 vssd1 vccd1 vccd1 _3406_/X sky130_fd_sc_hd__or3_1
X_3337_ _4541_/Q _3396_/A2 _3335_/X _3336_/X vssd1 vssd1 vccd1 vccd1 _4541_/D sky130_fd_sc_hd__a22o_1
XPHY_EDGE_ROW_37_Left_125 vssd1 vssd1 vccd1 vccd1 sky130_fd_sc_hd__decap_3
XANTENNA__4159__S _4231_/C vssd1 vssd1 vccd1 vccd1 sky130_fd_sc_hd__diode_2
XTAP_TAPCELL_ROW_5_238 vssd1 vccd1 sky130_fd_sc_hd__tapvpwrvgnd_1
XANTENNA_fanout292_A _4033_/C vssd1 vssd1 vccd1 vccd1 sky130_fd_sc_hd__diode_2
XFILLER_85_267 vssd1 vssd1 vccd1 vccd1 sky130_fd_sc_hd__fill_1
XFILLER_85_245 vssd1 vssd1 vccd1 vccd1 sky130_fd_sc_hd__decap_8
X_3268_ _4545_/Q _4586_/Q vssd1 vssd1 vccd1 vccd1 _3268_/Y sky130_fd_sc_hd__nand2_1
XTAP_TAPCELL_ROW_84_947 vssd1 vccd1 sky130_fd_sc_hd__tapvpwrvgnd_1
XFILLER_73_418 vssd1 vssd1 vccd1 vccd1 sky130_fd_sc_hd__fill_2
X_2219_ _4462_/Q vssd1 vssd1 vccd1 vccd1 _2219_/Y sky130_fd_sc_hd__inv_2
X_3199_ _4561_/Q _4602_/Q vssd1 vssd1 vccd1 vccd1 _3202_/A sky130_fd_sc_hd__and2_1
XFILLER_26_334 vssd1 vssd1 vccd1 vccd1 sky130_fd_sc_hd__decap_3
XFILLER_26_356 vssd1 vssd1 vccd1 vccd1 sky130_fd_sc_hd__decap_8
XANTENNA__2407__S _2421_/S vssd1 vssd1 vccd1 vccd1 sky130_fd_sc_hd__diode_2
XFILLER_53_164 vssd1 vssd1 vccd1 vccd1 sky130_fd_sc_hd__decap_4
XPHY_EDGE_ROW_46_Left_134 vssd1 vssd1 vccd1 vccd1 sky130_fd_sc_hd__decap_3
XFILLER_14_99 vssd1 vssd1 vccd1 vccd1 sky130_fd_sc_hd__fill_1
XPHY_EDGE_ROW_55_Left_143 vssd1 vssd1 vccd1 vccd1 sky130_fd_sc_hd__decap_3
XANTENNA_input20_A s_axis_tdata[25] vssd1 vssd1 vccd1 vccd1 sky130_fd_sc_hd__diode_2
XFILLER_76_289 vssd1 vssd1 vccd1 vccd1 sky130_fd_sc_hd__decap_6
XTAP_TAPCELL_ROW_47_616 vssd1 vccd1 sky130_fd_sc_hd__tapvpwrvgnd_1
XFILLER_55_40 vssd1 vssd1 vccd1 vccd1 sky130_fd_sc_hd__fill_1
XFILLER_32_304 vssd1 vssd1 vccd1 vccd1 sky130_fd_sc_hd__decap_4
XPHY_EDGE_ROW_64_Left_152 vssd1 vssd1 vccd1 vccd1 sky130_fd_sc_hd__decap_3
XTAP_TAPCELL_ROW_55_682 vssd1 vccd1 sky130_fd_sc_hd__tapvpwrvgnd_1
XFILLER_71_61 vssd1 vssd1 vccd1 vccd1 sky130_fd_sc_hd__decap_8
X_2570_ _2571_/A _2571_/B hold79/A vssd1 vssd1 vccd1 vccd1 _2572_/A sky130_fd_sc_hd__o21bai_1
XPHY_EDGE_ROW_73_Left_161 vssd1 vssd1 vccd1 vccd1 sky130_fd_sc_hd__decap_3
XANTENNA__3940__A1 _3946_/A1 vssd1 vssd1 vccd1 vccd1 sky130_fd_sc_hd__diode_2
X_4240_ _4371_/A _4240_/A2 _4240_/B1 vssd1 vssd1 vccd1 vccd1 _4240_/Y sky130_fd_sc_hd__o21ai_1
X_4171_ _4171_/A0 _4171_/A1 _4803_/Q vssd1 vssd1 vccd1 vccd1 _4171_/X sky130_fd_sc_hd__mux2_1
X_3122_ _3150_/B _3122_/B vssd1 vssd1 vccd1 vccd1 _3123_/B sky130_fd_sc_hd__nor2_1
XFILLER_67_223 vssd1 vssd1 vccd1 vccd1 sky130_fd_sc_hd__fill_1
XANTENNA__2900__C1 _4377_/C1 vssd1 vssd1 vccd1 vccd1 sky130_fd_sc_hd__diode_2
XTAP_TAPCELL_ROW_2_208 vssd1 vccd1 sky130_fd_sc_hd__tapvpwrvgnd_1
X_3053_ _3053_/A _3145_/A vssd1 vssd1 vccd1 vccd1 _3055_/C sky130_fd_sc_hd__xnor2_1
XFILLER_67_289 vssd1 vssd1 vccd1 vccd1 sky130_fd_sc_hd__fill_1
XPHY_EDGE_ROW_82_Left_170 vssd1 vssd1 vccd1 vccd1 sky130_fd_sc_hd__decap_3
XTAP_TAPCELL_ROW_81_917 vssd1 vccd1 sky130_fd_sc_hd__tapvpwrvgnd_1
XTAP_TAPCELL_ROW_18_351 vssd1 vccd1 sky130_fd_sc_hd__tapvpwrvgnd_1
XFILLER_23_326 vssd1 vssd1 vccd1 vccd1 sky130_fd_sc_hd__fill_2
X_3955_ hold154/X _3995_/B2 _3954_/X vssd1 vssd1 vccd1 vccd1 _4678_/D sky130_fd_sc_hd__o21a_1
XFILLER_23_359 vssd1 vssd1 vccd1 vccd1 sky130_fd_sc_hd__fill_1
X_2906_ _2873_/A _3862_/B _2949_/B _2905_/B vssd1 vssd1 vccd1 vccd1 _2907_/B sky130_fd_sc_hd__o2bb2a_1
X_3886_ _4167_/A0 hold117/X _3886_/S vssd1 vssd1 vccd1 vccd1 _4654_/D sky130_fd_sc_hd__mux2_1
XANTENNA__4184__A1 _4313_/S vssd1 vssd1 vccd1 vccd1 sky130_fd_sc_hd__diode_2
X_2837_ _2833_/X _2835_/Y _2872_/A vssd1 vssd1 vccd1 vccd1 _2840_/B sky130_fd_sc_hd__o21ai_1
XANTENNA_fanout305_A _4800_/Q vssd1 vssd1 vccd1 vccd1 sky130_fd_sc_hd__diode_2
X_2768_ _2770_/A _4699_/Q vssd1 vssd1 vccd1 vccd1 _2771_/C sky130_fd_sc_hd__and2_1
XANTENNA__3931__A1 _2274_/B vssd1 vssd1 vccd1 vccd1 sky130_fd_sc_hd__diode_2
X_2699_ _4697_/Q _4684_/Q vssd1 vssd1 vccd1 vccd1 _2699_/X sky130_fd_sc_hd__and2_1
X_4507_ _4579_/CLK _4507_/D fanout434/X vssd1 vssd1 vccd1 vccd1 hold17/A sky130_fd_sc_hd__dfrtp_1
X_4438_ _4580_/CLK _4438_/D fanout435/X vssd1 vssd1 vccd1 vccd1 hold19/A sky130_fd_sc_hd__dfrtp_1
X_4369_ _4368_/A _4372_/B _4369_/B1 vssd1 vssd1 vccd1 vccd1 _4369_/Y sky130_fd_sc_hd__o21ai_1
XFILLER_58_267 vccd1 vssd1 vccd1 vssd1 sky130_ef_sc_hd__decap_12
XFILLER_73_237 vssd1 vssd1 vccd1 vccd1 sky130_fd_sc_hd__decap_3
XANTENNA__3998__A1 _4064_/D vssd1 vssd1 vccd1 vccd1 sky130_fd_sc_hd__diode_2
XFILLER_26_197 vssd1 vssd1 vccd1 vccd1 sky130_fd_sc_hd__fill_1
XFILLER_41_53 vssd1 vssd1 vccd1 vccd1 sky130_fd_sc_hd__fill_1
XFILLER_49_212 vssd1 vssd1 vccd1 vccd1 sky130_fd_sc_hd__decap_8
XANTENNA__4100__B _4104_/B vssd1 vssd1 vccd1 vccd1 sky130_fd_sc_hd__diode_2
XFILLER_37_429 vccd1 vssd1 vccd1 vssd1 sky130_ef_sc_hd__decap_12
XANTENNA__3438__B1 _3460_/B1 vssd1 vssd1 vccd1 vccd1 sky130_fd_sc_hd__diode_2
XFILLER_66_83 vssd1 vssd1 vccd1 vccd1 sky130_fd_sc_hd__fill_1
XFILLER_45_473 vssd1 vssd1 vccd1 vccd1 sky130_fd_sc_hd__fill_1
XFILLER_17_175 vssd1 vssd1 vccd1 vccd1 sky130_fd_sc_hd__fill_1
XFILLER_17_186 vssd1 vssd1 vccd1 vccd1 sky130_fd_sc_hd__fill_1
XFILLER_32_112 vssd1 vssd1 vccd1 vccd1 sky130_fd_sc_hd__decap_4
XFILLER_45_495 vssd1 vssd1 vccd1 vccd1 sky130_fd_sc_hd__fill_1
XFILLER_60_421 vssd1 vssd1 vccd1 vccd1 sky130_fd_sc_hd__fill_2
XTAP_TAPCELL_ROW_15_321 vssd1 vccd1 sky130_fd_sc_hd__tapvpwrvgnd_1
X_3740_ _3740_/A _3740_/B vssd1 vssd1 vccd1 vccd1 _3740_/Y sky130_fd_sc_hd__xnor2_1
XFILLER_20_307 vssd1 vssd1 vccd1 vccd1 sky130_fd_sc_hd__fill_1
XFILLER_32_167 vssd1 vssd1 vccd1 vccd1 sky130_fd_sc_hd__decap_4
X_3671_ _3670_/Y _4599_/Q _3735_/S vssd1 vssd1 vccd1 vccd1 _4599_/D sky130_fd_sc_hd__mux2_1
X_2622_ _2622_/A _2622_/B vssd1 vssd1 vccd1 vccd1 _2623_/B sky130_fd_sc_hd__and2_1
X_2553_ _2554_/A _2554_/B vssd1 vssd1 vccd1 vccd1 _2553_/Y sky130_fd_sc_hd__nand2_1
X_2484_ _4456_/Q _2464_/B _2462_/Y vssd1 vssd1 vccd1 vccd1 _2487_/A sky130_fd_sc_hd__a21bo_1
X_4223_ _4243_/A2 _4239_/B _4223_/C _4223_/D vssd1 vssd1 vccd1 vccd1 _4223_/X sky130_fd_sc_hd__and4b_1
X_4154_ _4151_/X _4152_/X _4153_/Y _4225_/B2 _4730_/Q vssd1 vssd1 vccd1 vccd1 _4730_/D
+ sky130_fd_sc_hd__o32a_1
XFILLER_83_502 vssd1 vssd1 vccd1 vccd1 sky130_fd_sc_hd__fill_2
X_3105_ _4769_/Q _4784_/Q _3130_/A vssd1 vssd1 vccd1 vccd1 _3105_/Y sky130_fd_sc_hd__a21oi_2
X_4085_ _4219_/C _4105_/A2 _4205_/B2 vssd1 vssd1 vccd1 vccd1 _4085_/Y sky130_fd_sc_hd__o21ai_1
X_3036_ _3036_/A _3036_/B vssd1 vssd1 vccd1 vccd1 _3037_/B sky130_fd_sc_hd__nor2_1
XFILLER_55_237 vccd1 vssd1 vccd1 vssd1 sky130_ef_sc_hd__decap_12
XFILLER_63_281 vssd1 vssd1 vccd1 vccd1 sky130_fd_sc_hd__decap_8
XANTENNA_clkbuf_leaf_24_clk_A clkbuf_2_3__f_clk/X vssd1 vssd1 vccd1 vccd1 sky130_fd_sc_hd__diode_2
XFILLER_23_178 vssd1 vssd1 vccd1 vccd1 sky130_fd_sc_hd__decap_6
XFILLER_51_487 vssd1 vssd1 vccd1 vccd1 sky130_fd_sc_hd__fill_1
X_3938_ _3872_/X _3971_/A1 _4332_/A vssd1 vssd1 vccd1 vccd1 _3938_/X sky130_fd_sc_hd__mux2_1
XANTENNA_fanout422_A fanout423/X vssd1 vssd1 vccd1 vccd1 sky130_fd_sc_hd__diode_2
X_3869_ _3868_/Y hold216/X _3869_/S vssd1 vssd1 vccd1 vccd1 _4647_/D sky130_fd_sc_hd__mux2_1
XTAP_TAPCELL_ROW_21_379 vssd1 vccd1 sky130_fd_sc_hd__tapvpwrvgnd_1
XANTENNA_fanout308_X _4227_/C vssd1 vssd1 vccd1 vccd1 sky130_fd_sc_hd__diode_2
XANTENNA_fanout210_X _2274_/A vssd1 vssd1 vccd1 vccd1 sky130_fd_sc_hd__diode_2
XANTENNA_clkbuf_leaf_39_clk_A clkload2/A vssd1 vssd1 vccd1 vccd1 sky130_fd_sc_hd__diode_2
XFILLER_3_517 vssd1 vssd1 vccd1 vccd1 sky130_fd_sc_hd__fill_2
XANTENNA__2420__S _2420_/S vssd1 vssd1 vccd1 vccd1 sky130_fd_sc_hd__diode_2
XFILLER_87_27 vssd1 vssd1 vccd1 vccd1 sky130_fd_sc_hd__fill_1
XFILLER_78_307 vssd1 vssd1 vccd1 vccd1 sky130_fd_sc_hd__fill_1
Xfanout320 _2311_/A vssd1 vssd1 vccd1 vccd1 _4071_/S sky130_fd_sc_hd__clkbuf_4
Xfanout331 _4332_/A vssd1 vssd1 vccd1 vccd1 _4064_/D sky130_fd_sc_hd__buf_2
Xfanout342 _4320_/A vssd1 vssd1 vccd1 vccd1 _4120_/D sky130_fd_sc_hd__clkbuf_4
Xfanout375 fanout376/X vssd1 vssd1 vccd1 vccd1 fanout375/X sky130_fd_sc_hd__clkbuf_4
Xfanout353 _4377_/B1 vssd1 vssd1 vccd1 vccd1 _3946_/A1 sky130_fd_sc_hd__clkbuf_4
Xfanout364 fanout368/X vssd1 vssd1 vccd1 vccd1 _3541_/B1 sky130_fd_sc_hd__buf_2
Xfanout397 fanout398/X vssd1 vssd1 vccd1 vccd1 fanout397/X sky130_fd_sc_hd__clkbuf_2
XANTENNA__4347__S _4352_/A vssd1 vssd1 vccd1 vccd1 sky130_fd_sc_hd__diode_2
XFILLER_19_429 vssd1 vssd1 vccd1 vccd1 sky130_fd_sc_hd__decap_3
Xfanout386 fanout388/X vssd1 vssd1 vccd1 vccd1 fanout386/X sky130_fd_sc_hd__clkbuf_4
XTAP_TAPCELL_ROW_57_700 vssd1 vccd1 sky130_fd_sc_hd__tapvpwrvgnd_1
XFILLER_27_440 vssd1 vssd1 vccd1 vccd1 sky130_fd_sc_hd__decap_8
XTAP_TAPCELL_ROW_29_446 vssd1 vccd1 sky130_fd_sc_hd__tapvpwrvgnd_1
XFILLER_54_292 vccd1 vssd1 vccd1 vssd1 sky130_ef_sc_hd__decap_12
XFILLER_14_156 vssd1 vssd1 vccd1 vccd1 sky130_fd_sc_hd__fill_1
XFILLER_52_85 vssd1 vssd1 vccd1 vccd1 sky130_fd_sc_hd__fill_2
Xinput17 s_axis_tdata[22] vssd1 vssd1 vccd1 vccd1 input17/X sky130_fd_sc_hd__clkbuf_1
Xinput28 s_axis_tdata[3] vssd1 vssd1 vccd1 vccd1 input28/X sky130_fd_sc_hd__clkbuf_1
XFILLER_69_307 vssd1 vssd1 vccd1 vccd1 sky130_fd_sc_hd__decap_8
XANTENNA__4257__S _4323_/S vssd1 vssd1 vccd1 vccd1 sky130_fd_sc_hd__diode_2
XFILLER_18_473 vssd1 vssd1 vccd1 vccd1 sky130_fd_sc_hd__decap_3
XANTENNA__2853__X _2857_/A vssd1 vssd1 vccd1 vccd1 sky130_fd_sc_hd__diode_2
XTAP_TAPCELL_ROW_63_758 vssd1 vccd1 sky130_fd_sc_hd__tapvpwrvgnd_1
XFILLER_33_443 vssd1 vssd1 vccd1 vccd1 sky130_fd_sc_hd__decap_4
XFILLER_45_292 vssd1 vssd1 vccd1 vccd1 sky130_fd_sc_hd__decap_3
XFILLER_60_251 vssd1 vssd1 vccd1 vccd1 sky130_fd_sc_hd__fill_1
X_4772_ _4774_/CLK _4772_/D fanout399/X vssd1 vssd1 vccd1 vccd1 _4772_/Q sky130_fd_sc_hd__dfrtp_1
X_3723_ _4531_/Q _4640_/Q vssd1 vssd1 vccd1 vccd1 _3743_/B sky130_fd_sc_hd__nor2_1
XANTENNA__4005__B _4037_/B vssd1 vssd1 vccd1 vccd1 sky130_fd_sc_hd__diode_2
X_3654_ _3654_/A _3656_/C vssd1 vssd1 vccd1 vccd1 _3654_/Y sky130_fd_sc_hd__xnor2_1
XANTENNA__4139__A1 _4167_/A1 vssd1 vssd1 vccd1 vccd1 sky130_fd_sc_hd__diode_2
X_2605_ _2604_/B _2604_/C _4462_/Q vssd1 vssd1 vccd1 vccd1 _2606_/B sky130_fd_sc_hd__o21ai_1
X_3585_ _4514_/Q _4623_/Q vssd1 vssd1 vccd1 vccd1 _3587_/A sky130_fd_sc_hd__and2_1
X_2536_ _4517_/Q _2565_/B2 _2524_/Y _2535_/Y vssd1 vssd1 vccd1 vccd1 _4517_/D sky130_fd_sc_hd__o22a_1
XFILLER_87_104 vssd1 vssd1 vccd1 vccd1 sky130_fd_sc_hd__decap_8
X_2467_ _4703_/Q _2467_/B vssd1 vssd1 vccd1 vccd1 _2468_/B sky130_fd_sc_hd__or2_1
X_4206_ _4214_/A0 _4210_/A1 _4273_/S vssd1 vssd1 vccd1 vccd1 _4206_/X sky130_fd_sc_hd__mux2_1
XANTENNA__4167__S _4372_/A vssd1 vssd1 vccd1 vccd1 sky130_fd_sc_hd__diode_2
X_2398_ hold8/X _2397_/X _2426_/S vssd1 vssd1 vccd1 vccd1 _4494_/D sky130_fd_sc_hd__mux2_1
X_4137_ _4203_/C _4173_/A2 _4138_/B1 vssd1 vssd1 vccd1 vccd1 _4137_/Y sky130_fd_sc_hd__o21ai_1
X_4068_ _4132_/C _4068_/B _4100_/C _4203_/C vssd1 vssd1 vccd1 vccd1 _4068_/X sky130_fd_sc_hd__and4b_1
X_3019_ _2873_/A _3862_/B _3061_/B _3018_/B vssd1 vssd1 vccd1 vccd1 _3019_/X sky130_fd_sc_hd__o2bb2a_1
XFILLER_24_421 vssd1 vssd1 vccd1 vccd1 sky130_fd_sc_hd__decap_4
XTAP_TAPCELL_ROW_26_427 vssd1 vccd1 sky130_fd_sc_hd__tapvpwrvgnd_1
XFILLER_43_218 vssd1 vssd1 vccd1 vccd1 sky130_fd_sc_hd__fill_1
XFILLER_36_281 vssd1 vssd1 vccd1 vccd1 sky130_fd_sc_hd__fill_2
XFILLER_36_292 vssd1 vssd1 vccd1 vccd1 sky130_fd_sc_hd__decap_4
XFILLER_51_240 vssd1 vssd1 vccd1 vccd1 sky130_fd_sc_hd__decap_8
XANTENNA__2415__S _2421_/S vssd1 vssd1 vccd1 vccd1 sky130_fd_sc_hd__diode_2
XTAP_TAPCELL_ROW_34_493 vssd1 vccd1 sky130_fd_sc_hd__tapvpwrvgnd_1
XANTENNA__3353__A2 _3425_/A2 vssd1 vssd1 vccd1 vccd1 sky130_fd_sc_hd__diode_2
XFILLER_3_369 vccd1 vssd1 vccd1 vssd1 sky130_ef_sc_hd__decap_12
Xfanout183 _3885_/Y vssd1 vssd1 vccd1 vccd1 _4167_/A0 sky130_fd_sc_hd__buf_2
Xfanout172 _3977_/X vssd1 vssd1 vccd1 vccd1 _4020_/A1 sky130_fd_sc_hd__buf_2
Xfanout161 _2273_/X vssd1 vssd1 vccd1 vccd1 _4338_/A2 sky130_fd_sc_hd__buf_2
Xfanout150 _4209_/B2 vssd1 vssd1 vccd1 vccd1 _4225_/B2 sky130_fd_sc_hd__clkbuf_2
XFILLER_86_170 vccd1 vssd1 vccd1 vssd1 sky130_ef_sc_hd__decap_12
Xfanout194 _2872_/Y vssd1 vssd1 vccd1 vccd1 _3863_/A2 sky130_fd_sc_hd__buf_1
XFILLER_74_365 vssd1 vssd1 vccd1 vccd1 sky130_fd_sc_hd__decap_8
XFILLER_74_354 vssd1 vssd1 vccd1 vccd1 sky130_fd_sc_hd__decap_3
XFILLER_34_207 vssd1 vssd1 vccd1 vccd1 sky130_fd_sc_hd__fill_2
XFILLER_42_251 vssd1 vssd1 vccd1 vccd1 sky130_fd_sc_hd__fill_1
XTAP_TAPCELL_ROW_60_728 vssd1 vccd1 sky130_fd_sc_hd__tapvpwrvgnd_1
XANTENNA__4369__A1 _4368_/A vssd1 vssd1 vccd1 vccd1 sky130_fd_sc_hd__diode_2
XFILLER_10_181 vssd1 vssd1 vccd1 vccd1 sky130_fd_sc_hd__decap_3
X_3370_ _3370_/A _3370_/B _3370_/C _3370_/D vssd1 vssd1 vccd1 vccd1 _3371_/B sky130_fd_sc_hd__and4_1
X_2321_ _2320_/Y _2319_/X _2318_/X hold225/X _2321_/B2 vssd1 vssd1 vccd1 vccd1 _4462_/D
+ sky130_fd_sc_hd__o32a_1
XFILLER_69_159 vssd1 vssd1 vccd1 vccd1 sky130_fd_sc_hd__decap_8
XFILLER_69_148 vssd1 vssd1 vccd1 vccd1 sky130_fd_sc_hd__fill_1
X_2252_ hold73/X _4560_/Q _2272_/S vssd1 vssd1 vccd1 vccd1 _4431_/D sky130_fd_sc_hd__mux2_1
XANTENNA__3501__C1 _3543_/A vssd1 vssd1 vccd1 vccd1 sky130_fd_sc_hd__diode_2
XANTENNA__2304__B1 _3928_/S vssd1 vssd1 vccd1 vccd1 sky130_fd_sc_hd__diode_2
XFILLER_26_3 vccd1 vssd1 vccd1 vssd1 sky130_ef_sc_hd__decap_12
XFILLER_53_505 vssd1 vssd1 vccd1 vccd1 sky130_fd_sc_hd__fill_2
XTAP_TAPCELL_ROW_76_872 vssd1 vccd1 sky130_fd_sc_hd__tapvpwrvgnd_1
XFILLER_80_346 vccd1 vssd1 vccd1 vssd1 sky130_ef_sc_hd__decap_12
XFILLER_33_251 vccd1 vssd1 vccd1 vssd1 sky130_ef_sc_hd__decap_12
X_4755_ _4771_/CLK _4755_/D fanout391/X vssd1 vssd1 vccd1 vccd1 _4755_/Q sky130_fd_sc_hd__dfrtp_2
XANTENNA_fanout120_A _2930_/A2 vssd1 vssd1 vccd1 vccd1 sky130_fd_sc_hd__diode_2
X_3706_ _4529_/Q _4638_/Q vssd1 vssd1 vccd1 vccd1 _3729_/B sky130_fd_sc_hd__xnor2_1
X_4686_ _4686_/CLK _4686_/D fanout384/X vssd1 vssd1 vccd1 vccd1 _4686_/Q sky130_fd_sc_hd__dfrtp_1
XANTENNA_fanout218_A _4377_/C1 vssd1 vssd1 vccd1 vccd1 sky130_fd_sc_hd__diode_2
X_3637_ _3643_/A _3643_/B _3643_/C _3632_/B _3621_/Y vssd1 vssd1 vccd1 vccd1 _3637_/Y
+ sky130_fd_sc_hd__o221ai_1
X_3568_ _3564_/X _3566_/Y _4619_/Q _3567_/B vssd1 vssd1 vccd1 vccd1 _3568_/X sky130_fd_sc_hd__a2bb2o_1
XFILLER_68_29 vssd1 vssd1 vccd1 vccd1 sky130_fd_sc_hd__fill_1
X_2519_ _2519_/A _2519_/B _4662_/Q vssd1 vssd1 vccd1 vccd1 _2519_/X sky130_fd_sc_hd__or3b_1
X_3499_ _3166_/A _3166_/B _3498_/B _3498_/C vssd1 vssd1 vccd1 vccd1 _3499_/X sky130_fd_sc_hd__a22o_1
XTAP_TAPCELL_ROW_39_541 vssd1 vccd1 sky130_fd_sc_hd__tapvpwrvgnd_1
XFILLER_12_457 vccd1 vssd1 vccd1 vssd1 sky130_ef_sc_hd__decap_12
XFILLER_33_76 vssd1 vssd1 vccd1 vccd1 sky130_fd_sc_hd__decap_8
XFILLER_79_424 vccd1 vssd1 vccd1 vssd1 sky130_ef_sc_hd__decap_12
Xhold6 hold6/A vssd1 vssd1 vccd1 vccd1 hold6/X sky130_fd_sc_hd__dlygate4sd3_1
XTAP_TAPCELL_ROW_73_842 vssd1 vccd1 sky130_fd_sc_hd__tapvpwrvgnd_1
XFILLER_70_390 vccd1 vssd1 vccd1 vssd1 sky130_ef_sc_hd__decap_12
X_2870_ _4685_/Q _4702_/Q vssd1 vssd1 vccd1 vccd1 _2872_/C sky130_fd_sc_hd__nand2b_1
XFILLER_30_287 vssd1 vssd1 vccd1 vccd1 sky130_fd_sc_hd__fill_1
XFILLER_11_490 vccd1 vssd1 vccd1 vssd1 sky130_ef_sc_hd__decap_12
X_4540_ _4668_/CLK _4540_/D fanout422/X vssd1 vssd1 vccd1 vccd1 _4540_/Q sky130_fd_sc_hd__dfrtp_1
Xclkbuf_leaf_10_clk clkload1/A vssd1 vssd1 vccd1 vccd1 _4745_/CLK sky130_fd_sc_hd__clkbuf_8
XFILLER_7_461 vccd1 vssd1 vccd1 vssd1 sky130_ef_sc_hd__decap_12
X_4471_ _4549_/CLK _4471_/D fanout415/X vssd1 vssd1 vccd1 vccd1 hold48/A sky130_fd_sc_hd__dfrtp_1
X_3422_ _3278_/X _3370_/D _3285_/Y _3293_/Y _3254_/X vssd1 vssd1 vccd1 vccd1 _3422_/X
+ sky130_fd_sc_hd__a311o_1
X_3353_ _4544_/Q _3425_/A2 _3351_/X _3352_/X vssd1 vssd1 vccd1 vccd1 _4544_/D sky130_fd_sc_hd__a22o_1
X_2304_ _2304_/A1 _2295_/C _2295_/B _3928_/S _2303_/Y vssd1 vssd1 vccd1 vccd1 _2304_/X
+ sky130_fd_sc_hd__a311o_1
X_3284_ _3393_/A _3284_/B _3380_/C _3284_/D vssd1 vssd1 vccd1 vccd1 _3286_/D sky130_fd_sc_hd__nand4_1
XFILLER_85_438 vssd1 vssd1 vccd1 vccd1 sky130_fd_sc_hd__decap_8
X_2235_ hold71/X _4543_/Q _2242_/S vssd1 vssd1 vccd1 vccd1 _4414_/D sky130_fd_sc_hd__mux2_1
XTAP_TAPCELL_ROW_36_511 vssd1 vccd1 sky130_fd_sc_hd__tapvpwrvgnd_1
XFILLER_80_110 vssd1 vssd1 vccd1 vccd1 sky130_fd_sc_hd__decap_4
XANTENNA_fanout168_A _4171_/A1 vssd1 vssd1 vccd1 vccd1 sky130_fd_sc_hd__diode_2
XFILLER_0_80 vssd1 vssd1 vccd1 vccd1 sky130_fd_sc_hd__fill_2
XANTENNA_fanout335_A _4328_/A vssd1 vssd1 vccd1 vccd1 sky130_fd_sc_hd__diode_2
X_4807_ _4808_/CLK _4807_/D fanout377/X vssd1 vssd1 vccd1 vccd1 _4807_/Q sky130_fd_sc_hd__dfrtp_1
XPHY_EDGE_ROW_3_Right_3 vssd1 vssd1 vccd1 vccd1 sky130_fd_sc_hd__decap_3
X_2999_ _3000_/A _3000_/B _3000_/C vssd1 vssd1 vccd1 vccd1 _3001_/A sky130_fd_sc_hd__a21oi_1
XFILLER_21_287 vccd1 vssd1 vccd1 vssd1 sky130_ef_sc_hd__decap_12
XANTENNA__4202__A0 _4214_/A0 vssd1 vssd1 vccd1 vccd1 sky130_fd_sc_hd__diode_2
X_4738_ clkload6/A _4738_/D fanout382/X vssd1 vssd1 vccd1 vccd1 _4738_/Q sky130_fd_sc_hd__dfrtp_1
X_4669_ _4669_/CLK _4669_/D fanout407/X vssd1 vssd1 vccd1 vccd1 hold86/A sky130_fd_sc_hd__dfrtp_1
XANTENNA__3872__X _3872_/X vssd1 vssd1 vccd1 vccd1 sky130_fd_sc_hd__diode_2
XFILLER_0_103 vssd1 vssd1 vccd1 vccd1 sky130_fd_sc_hd__decap_8
XTAP_TAPCELL_ROW_8_258 vssd1 vccd1 sky130_fd_sc_hd__tapvpwrvgnd_1
XFILLER_0_125 vccd1 vssd1 vccd1 vssd1 sky130_ef_sc_hd__decap_12
XANTENNA__3989__A_N _4064_/C vssd1 vssd1 vccd1 vccd1 sky130_fd_sc_hd__diode_2
XTAP_TAPCELL_ROW_87_978 vssd1 vccd1 sky130_fd_sc_hd__tapvpwrvgnd_1
XFILLER_29_365 vssd1 vssd1 vccd1 vccd1 sky130_fd_sc_hd__decap_3
XANTENNA__4355__S _4360_/A vssd1 vssd1 vccd1 vccd1 sky130_fd_sc_hd__diode_2
XFILLER_71_121 vssd1 vssd1 vccd1 vccd1 sky130_fd_sc_hd__decap_3
XFILLER_44_335 vssd1 vssd1 vccd1 vccd1 sky130_fd_sc_hd__fill_1
XFILLER_56_195 vssd1 vssd1 vccd1 vccd1 sky130_fd_sc_hd__fill_1
XFILLER_71_176 vccd1 vssd1 vccd1 vssd1 sky130_ef_sc_hd__decap_12
XTAP_TAPCELL_ROW_70_823 vssd1 vccd1 sky130_fd_sc_hd__tapvpwrvgnd_1
XTAP_TAPCELL_ROW_42_569 vssd1 vccd1 sky130_fd_sc_hd__tapvpwrvgnd_1
XFILLER_12_265 vssd1 vssd1 vccd1 vccd1 sky130_fd_sc_hd__decap_4
XFILLER_8_236 vssd1 vssd1 vccd1 vccd1 sky130_fd_sc_hd__decap_8
XFILLER_8_247 vssd1 vssd1 vccd1 vccd1 sky130_fd_sc_hd__decap_4
XFILLER_60_85 vssd1 vssd1 vccd1 vccd1 sky130_fd_sc_hd__fill_1
XFILLER_5_69 vccd1 vssd1 vccd1 vssd1 sky130_ef_sc_hd__decap_12
XANTENNA__4144__A_N _4239_/D vssd1 vssd1 vccd1 vccd1 sky130_fd_sc_hd__diode_2
XFILLER_35_335 vssd1 vssd1 vccd1 vccd1 sky130_fd_sc_hd__fill_1
X_3971_ _3872_/X _3971_/A1 _4036_/S vssd1 vssd1 vccd1 vccd1 _3971_/X sky130_fd_sc_hd__mux2_1
X_2922_ _2975_/A _2922_/B vssd1 vssd1 vccd1 vccd1 _2924_/C sky130_fd_sc_hd__nand2_1
X_2853_ _4730_/Q _2811_/B _2810_/A vssd1 vssd1 vccd1 vccd1 _2857_/A sky130_fd_sc_hd__a21o_1
X_2784_ _2739_/B _2745_/A _2745_/B _2737_/X vssd1 vssd1 vccd1 vccd1 _2795_/A sky130_fd_sc_hd__a31oi_2
XANTENNA__4013__B _4037_/B vssd1 vssd1 vccd1 vccd1 sky130_fd_sc_hd__diode_2
X_4523_ _4631_/CLK _4523_/D fanout411/X vssd1 vssd1 vccd1 vccd1 _4523_/Q sky130_fd_sc_hd__dfrtp_1
Xhold203 _4762_/Q vssd1 vssd1 vccd1 vccd1 hold203/X sky130_fd_sc_hd__dlygate4sd3_1
Xhold214 _4692_/Q vssd1 vssd1 vccd1 vccd1 hold214/X sky130_fd_sc_hd__dlygate4sd3_1
Xhold225 _4462_/Q vssd1 vssd1 vccd1 vccd1 hold225/X sky130_fd_sc_hd__dlygate4sd3_1
X_4454_ _4687_/CLK _4454_/D fanout383/X vssd1 vssd1 vccd1 vccd1 _4454_/Q sky130_fd_sc_hd__dfrtp_1
X_4385_ _4005_/D input31/X _4400_/S vssd1 vssd1 vccd1 vccd1 _4794_/D sky130_fd_sc_hd__mux2_1
X_3405_ _4554_/Q _4595_/Q _3403_/Y vssd1 vssd1 vccd1 vccd1 _3405_/Y sky130_fd_sc_hd__o21ai_1
X_3336_ _4582_/Q _3384_/A2 _3395_/B1 _3561_/C vssd1 vssd1 vccd1 vccd1 _3336_/X sky130_fd_sc_hd__o211a_1
XANTENNA__4737__Q _4737_/Q vssd1 vssd1 vccd1 vccd1 sky130_fd_sc_hd__diode_2
X_3267_ _3266_/A _3266_/B _3266_/C _3258_/X vssd1 vssd1 vccd1 vccd1 _3354_/A sky130_fd_sc_hd__a31oi_4
XANTENNA_fanout285_A _4009_/A_N vssd1 vssd1 vccd1 vccd1 sky130_fd_sc_hd__diode_2
XFILLER_85_279 vssd1 vssd1 vccd1 vccd1 sky130_fd_sc_hd__fill_1
X_2218_ _4463_/Q vssd1 vssd1 vccd1 vccd1 _2629_/B sky130_fd_sc_hd__inv_2
X_3198_ _4562_/Q _4603_/Q vssd1 vssd1 vccd1 vccd1 _3447_/A sky130_fd_sc_hd__xor2_1
XTAP_TAPCELL_ROW_84_948 vssd1 vccd1 sky130_fd_sc_hd__tapvpwrvgnd_1
XFILLER_26_346 vssd1 vssd1 vccd1 vccd1 sky130_fd_sc_hd__fill_2
XFILLER_41_327 vssd1 vssd1 vccd1 vccd1 sky130_fd_sc_hd__fill_1
XANTENNA_fanout240_X _2271_/S vssd1 vssd1 vccd1 vccd1 sky130_fd_sc_hd__diode_2
XANTENNA_fanout338_X _4119_/S vssd1 vssd1 vccd1 vccd1 sky130_fd_sc_hd__diode_2
XFILLER_30_55 vssd1 vssd1 vccd1 vccd1 sky130_fd_sc_hd__fill_1
XANTENNA__4017__A_N _4100_/C vssd1 vssd1 vccd1 vccd1 sky130_fd_sc_hd__diode_2
XFILLER_76_257 vssd1 vssd1 vccd1 vccd1 sky130_fd_sc_hd__fill_1
XFILLER_76_246 vssd1 vssd1 vccd1 vccd1 sky130_fd_sc_hd__decap_6
XANTENNA_input13_A s_axis_tdata[19] vssd1 vssd1 vccd1 vccd1 sky130_fd_sc_hd__diode_2
XFILLER_29_184 vccd1 vssd1 vccd1 vssd1 sky130_ef_sc_hd__decap_12
XFILLER_44_110 vccd1 vssd1 vccd1 vssd1 sky130_ef_sc_hd__decap_12
XFILLER_55_96 vssd1 vssd1 vccd1 vccd1 sky130_fd_sc_hd__decap_8
XFILLER_44_176 vssd1 vssd1 vccd1 vccd1 sky130_fd_sc_hd__fill_1
XTAP_TAPCELL_ROW_55_683 vssd1 vccd1 sky130_fd_sc_hd__tapvpwrvgnd_1
X_4170_ _4167_/X _4168_/X _4169_/Y _4240_/B1 hold126/X vssd1 vssd1 vccd1 vccd1 _4734_/D
+ sky130_fd_sc_hd__o32a_1
X_3121_ _4770_/Q _4786_/Q vssd1 vssd1 vccd1 vccd1 _3122_/B sky130_fd_sc_hd__nor2_1
XANTENNA__2900__B1 _4666_/Q vssd1 vssd1 vccd1 vccd1 sky130_fd_sc_hd__diode_2
XFILLER_67_257 vssd1 vssd1 vccd1 vccd1 sky130_fd_sc_hd__fill_1
XTAP_TAPCELL_ROW_2_209 vssd1 vccd1 sky130_fd_sc_hd__tapvpwrvgnd_1
X_3052_ _3862_/C _3862_/D vssd1 vssd1 vccd1 vccd1 _3145_/A sky130_fd_sc_hd__and2_2
XFILLER_82_238 vssd1 vssd1 vccd1 vccd1 sky130_fd_sc_hd__fill_1
XTAP_TAPCELL_ROW_81_918 vssd1 vccd1 sky130_fd_sc_hd__tapvpwrvgnd_1
XFILLER_63_441 vssd1 vssd1 vccd1 vccd1 sky130_fd_sc_hd__decap_6
XTAP_TAPCELL_ROW_18_352 vssd1 vccd1 sky130_fd_sc_hd__tapvpwrvgnd_1
X_3954_ _4017_/D _3974_/A1 _3953_/Y _3886_/S vssd1 vssd1 vccd1 vccd1 _3954_/X sky130_fd_sc_hd__a211o_1
X_2905_ _2949_/B _2905_/B _3074_/C vssd1 vssd1 vccd1 vccd1 _2907_/A sky130_fd_sc_hd__nor3_1
X_3885_ _4136_/B _4116_/D _3884_/Y vssd1 vssd1 vccd1 vccd1 _3885_/Y sky130_fd_sc_hd__a21oi_1
X_2836_ _2835_/Y _4468_/Q _2836_/C vssd1 vssd1 vccd1 vccd1 _2840_/A sky130_fd_sc_hd__nand3b_1
XANTENNA__4184__A2 _4212_/A2 vssd1 vssd1 vccd1 vccd1 sky130_fd_sc_hd__diode_2
X_2767_ _2767_/A _4729_/Q _2767_/C vssd1 vssd1 vccd1 vccd1 _2767_/Y sky130_fd_sc_hd__nand3_4
XANTENNA_fanout200_A _2424_/S vssd1 vssd1 vccd1 vccd1 sky130_fd_sc_hd__diode_2
X_4506_ _4579_/CLK _4506_/D fanout433/X vssd1 vssd1 vccd1 vccd1 hold55/A sky130_fd_sc_hd__dfrtp_1
X_2698_ _2694_/X _2696_/Y _4772_/Q vssd1 vssd1 vccd1 vccd1 _2705_/B sky130_fd_sc_hd__o21bai_1
X_4437_ _4605_/CLK _4437_/D fanout435/X vssd1 vssd1 vccd1 vccd1 hold41/A sky130_fd_sc_hd__dfrtp_1
X_4368_ _4368_/A _4371_/B _4371_/C vssd1 vssd1 vccd1 vccd1 _4368_/X sky130_fd_sc_hd__and3_1
XANTENNA_input5_A s_axis_tdata[11] vssd1 vssd1 vccd1 vccd1 sky130_fd_sc_hd__diode_2
X_4299_ _4364_/A _4307_/A2 _4369_/B1 vssd1 vssd1 vccd1 vccd1 _4299_/Y sky130_fd_sc_hd__o21ai_1
X_3319_ _3531_/A _3319_/B vssd1 vssd1 vccd1 vccd1 _3528_/A sky130_fd_sc_hd__and2_1
XANTENNA_fanout288_X _4009_/A_N vssd1 vssd1 vccd1 vccd1 sky130_fd_sc_hd__diode_2
XFILLER_58_279 vssd1 vssd1 vccd1 vccd1 sky130_fd_sc_hd__decap_6
XANTENNA__2418__S _2420_/S vssd1 vssd1 vccd1 vccd1 sky130_fd_sc_hd__diode_2
XANTENNA__3998__A2 _4022_/A2 vssd1 vssd1 vccd1 vccd1 sky130_fd_sc_hd__diode_2
XFILLER_26_154 vccd1 vssd1 vccd1 vssd1 sky130_ef_sc_hd__decap_12
XFILLER_54_452 vssd1 vssd1 vccd1 vccd1 sky130_fd_sc_hd__fill_2
XFILLER_41_102 vssd1 vssd1 vccd1 vccd1 sky130_fd_sc_hd__decap_8
XFILLER_41_113 vccd1 vssd1 vccd1 vssd1 sky130_ef_sc_hd__decap_12
XFILLER_54_474 vssd1 vssd1 vccd1 vccd1 sky130_fd_sc_hd__fill_2
XFILLER_14_349 vssd1 vssd1 vccd1 vccd1 sky130_fd_sc_hd__decap_3
XTAP_TAPCELL_ROW_52_653 vssd1 vccd1 sky130_fd_sc_hd__tapvpwrvgnd_1
XANTENNA__3922__A2 _4666_/Q vssd1 vssd1 vccd1 vccd1 sky130_fd_sc_hd__diode_2
XANTENNA__4100__C _4100_/C vssd1 vssd1 vccd1 vccd1 sky130_fd_sc_hd__diode_2
XFILLER_64_216 vssd1 vssd1 vccd1 vccd1 sky130_fd_sc_hd__decap_6
XANTENNA__3438__A1 _3460_/A1 vssd1 vssd1 vccd1 vccd1 sky130_fd_sc_hd__diode_2
XFILLER_49_279 vssd1 vssd1 vccd1 vccd1 sky130_fd_sc_hd__fill_1
XANTENNA__2836__B _4468_/Q vssd1 vssd1 vccd1 vccd1 sky130_fd_sc_hd__diode_2
XFILLER_72_293 vssd1 vssd1 vccd1 vccd1 sky130_fd_sc_hd__decap_8
XTAP_TAPCELL_ROW_15_322 vssd1 vccd1 sky130_fd_sc_hd__tapvpwrvgnd_1
X_3670_ _3670_/A _3670_/B vssd1 vssd1 vccd1 vccd1 _3670_/Y sky130_fd_sc_hd__xnor2_1
X_2621_ _2621_/A _2621_/B _2621_/C vssd1 vssd1 vccd1 vccd1 _2622_/B sky130_fd_sc_hd__nand3_1
X_2552_ _2552_/A _2552_/B vssd1 vssd1 vccd1 vccd1 _2554_/B sky130_fd_sc_hd__xnor2_2
XFILLER_56_3 vssd1 vssd1 vccd1 vccd1 sky130_fd_sc_hd__fill_2
XANTENNA__2299__A _4064_/D vssd1 vssd1 vccd1 vccd1 sky130_fd_sc_hd__diode_2
X_4222_ _4238_/A0 _4238_/A1 _4227_/C vssd1 vssd1 vccd1 vccd1 _4222_/X sky130_fd_sc_hd__mux2_1
X_2483_ _4704_/Q _2483_/B vssd1 vssd1 vccd1 vccd1 _2489_/B sky130_fd_sc_hd__xnor2_2
X_4153_ _4219_/C _4176_/A2 _4225_/B2 vssd1 vssd1 vccd1 vccd1 _4153_/Y sky130_fd_sc_hd__o21ai_1
X_3104_ _3104_/A _3104_/B vssd1 vssd1 vccd1 vccd1 _3112_/C sky130_fd_sc_hd__nand2_1
XFILLER_28_419 vssd1 vssd1 vccd1 vccd1 sky130_fd_sc_hd__fill_1
X_4084_ _4148_/C _4104_/B _4100_/C _4219_/C vssd1 vssd1 vccd1 vccd1 _4084_/X sky130_fd_sc_hd__and4b_1
X_3035_ _3031_/X _3035_/B _3035_/C vssd1 vssd1 vccd1 vccd1 _3036_/B sky130_fd_sc_hd__and3b_1
XFILLER_55_249 vccd1 vssd1 vccd1 vssd1 sky130_ef_sc_hd__decap_12
XFILLER_48_290 vssd1 vssd1 vccd1 vccd1 sky130_fd_sc_hd__fill_1
XFILLER_63_271 vssd1 vssd1 vccd1 vccd1 sky130_fd_sc_hd__decap_8
X_3937_ _2274_/B _3943_/A2 _3935_/X _3936_/X vssd1 vssd1 vccd1 vccd1 _4672_/D sky130_fd_sc_hd__a31o_1
X_3868_ _3868_/A _3868_/B vssd1 vssd1 vccd1 vccd1 _3868_/Y sky130_fd_sc_hd__xnor2_1
X_3799_ _4651_/Q _3798_/B _3795_/S vssd1 vssd1 vccd1 vccd1 _3799_/Y sky130_fd_sc_hd__a21oi_1
X_2819_ _4759_/Q _4774_/Q _2820_/A vssd1 vssd1 vccd1 vccd1 _2819_/Y sky130_fd_sc_hd__a21oi_1
XANTENNA__4157__A2 _4176_/A2 vssd1 vssd1 vccd1 vccd1 sky130_fd_sc_hd__diode_2
Xfanout310 _4798_/Q vssd1 vssd1 vccd1 vccd1 _4223_/C sky130_fd_sc_hd__buf_2
Xfanout332 _4332_/A vssd1 vssd1 vccd1 vccd1 _4266_/D sky130_fd_sc_hd__buf_2
Xfanout321 _2311_/A vssd1 vssd1 vccd1 vccd1 _4273_/S sky130_fd_sc_hd__buf_2
Xfanout343 _4320_/A vssd1 vssd1 vccd1 vccd1 _3985_/D sky130_fd_sc_hd__clkbuf_2
Xfanout354 _4377_/B1 vssd1 vssd1 vccd1 vccd1 _2274_/B sky130_fd_sc_hd__buf_2
Xfanout365 fanout368/X vssd1 vssd1 vccd1 vccd1 _3162_/B sky130_fd_sc_hd__buf_1
XFILLER_86_363 vssd1 vssd1 vccd1 vccd1 sky130_fd_sc_hd__fill_1
Xfanout376 fanout379/X vssd1 vssd1 vccd1 vccd1 fanout376/X sky130_fd_sc_hd__clkbuf_4
Xfanout387 fanout388/X vssd1 vssd1 vccd1 vccd1 fanout387/X sky130_fd_sc_hd__clkbuf_2
Xfanout398 fanout404/X vssd1 vssd1 vccd1 vccd1 fanout398/X sky130_fd_sc_hd__clkbuf_2
XTAP_TAPCELL_ROW_57_701 vssd1 vccd1 sky130_fd_sc_hd__tapvpwrvgnd_1
XFILLER_61_208 vssd1 vssd1 vccd1 vccd1 sky130_fd_sc_hd__decap_4
XTAP_TAPCELL_ROW_29_447 vssd1 vccd1 sky130_fd_sc_hd__tapvpwrvgnd_1
XANTENNA__4093__A1 _4227_/C vssd1 vssd1 vccd1 vccd1 sky130_fd_sc_hd__diode_2
XPHY_EDGE_ROW_1_Left_89 vssd1 vssd1 vccd1 vccd1 sky130_fd_sc_hd__decap_3
XFILLER_54_271 vccd1 vssd1 vccd1 vssd1 sky130_ef_sc_hd__decap_12
XANTENNA__4363__S _4368_/A vssd1 vssd1 vccd1 vccd1 sky130_fd_sc_hd__diode_2
XFILLER_52_75 vssd1 vssd1 vccd1 vccd1 sky130_fd_sc_hd__fill_1
XFILLER_10_341 vssd1 vssd1 vccd1 vccd1 sky130_fd_sc_hd__fill_1
Xinput18 s_axis_tdata[23] vssd1 vssd1 vccd1 vccd1 input18/X sky130_fd_sc_hd__clkbuf_1
XFILLER_10_363 vssd1 vssd1 vccd1 vccd1 sky130_fd_sc_hd__fill_1
Xinput29 s_axis_tdata[4] vssd1 vssd1 vccd1 vccd1 input29/X sky130_fd_sc_hd__clkbuf_1
XFILLER_6_334 vssd1 vssd1 vccd1 vccd1 sky130_fd_sc_hd__decap_3
XFILLER_65_503 vssd1 vssd1 vccd1 vccd1 sky130_fd_sc_hd__fill_1
XTAP_TAPCELL_ROW_63_759 vssd1 vccd1 sky130_fd_sc_hd__tapvpwrvgnd_1
XANTENNA__4273__S _4273_/S vssd1 vssd1 vccd1 vccd1 sky130_fd_sc_hd__diode_2
XFILLER_60_274 vccd1 vssd1 vccd1 vssd1 sky130_ef_sc_hd__decap_12
XANTENNA__2340__C_N _4036_/S vssd1 vssd1 vccd1 vccd1 sky130_fd_sc_hd__diode_2
XFILLER_20_127 vssd1 vssd1 vccd1 vccd1 sky130_fd_sc_hd__fill_1
XFILLER_20_138 vssd1 vssd1 vccd1 vccd1 sky130_fd_sc_hd__fill_2
X_4771_ _4771_/CLK _4771_/D fanout391/X vssd1 vssd1 vccd1 vccd1 _4771_/Q sky130_fd_sc_hd__dfrtp_1
X_3722_ _4531_/Q _4640_/Q vssd1 vssd1 vccd1 vccd1 _3722_/Y sky130_fd_sc_hd__nand2_1
XANTENNA__4005__C _4037_/C vssd1 vssd1 vccd1 vccd1 sky130_fd_sc_hd__diode_2
X_3653_ _3653_/A _3653_/B vssd1 vssd1 vccd1 vccd1 _3656_/C sky130_fd_sc_hd__nor2_1
X_2604_ _4462_/Q _2604_/B _2604_/C vssd1 vssd1 vccd1 vccd1 _2604_/Y sky130_fd_sc_hd__nor3_1
X_3584_ _4588_/Q _3603_/S _3583_/X _3582_/Y vssd1 vssd1 vccd1 vccd1 _4588_/D sky130_fd_sc_hd__a22o_1
X_2535_ _2532_/X _2534_/Y _2565_/B2 vssd1 vssd1 vccd1 vccd1 _2535_/Y sky130_fd_sc_hd__o21ai_1
XANTENNA__4021__B _4037_/B vssd1 vssd1 vccd1 vccd1 sky130_fd_sc_hd__diode_2
X_2466_ _4703_/Q _2467_/B vssd1 vssd1 vccd1 vccd1 _2468_/A sky130_fd_sc_hd__nand2_1
XANTENNA__4311__A2 _4361_/B1 vssd1 vssd1 vccd1 vccd1 sky130_fd_sc_hd__diode_2
X_4205_ _4204_/Y _4203_/X _4202_/X hold220/X _4205_/B2 vssd1 vssd1 vccd1 vccd1 _4743_/D
+ sky130_fd_sc_hd__o32a_1
X_4136_ _4140_/A_N _4136_/B _4148_/C _4203_/C vssd1 vssd1 vccd1 vccd1 _4136_/X sky130_fd_sc_hd__and4b_1
X_2397_ _4566_/Q hold41/A _2425_/S vssd1 vssd1 vccd1 vccd1 _2397_/X sky130_fd_sc_hd__mux2_1
X_4067_ _4103_/A0 _4083_/A1 _4274_/D vssd1 vssd1 vccd1 vccd1 _4067_/X sky130_fd_sc_hd__mux2_1
XFILLER_83_399 vccd1 vssd1 vccd1 vssd1 sky130_ef_sc_hd__decap_12
X_3018_ _3061_/B _3018_/B _3074_/C vssd1 vssd1 vccd1 vccd1 _3021_/A sky130_fd_sc_hd__or3_1
XANTENNA__2625__A2 _3870_/B1 vssd1 vssd1 vccd1 vccd1 sky130_fd_sc_hd__diode_2
XFILLER_51_263 vccd1 vssd1 vccd1 vssd1 sky130_ef_sc_hd__decap_12
XTAP_TAPCELL_ROW_34_494 vssd1 vccd1 sky130_fd_sc_hd__tapvpwrvgnd_1
XANTENNA_fanout320_X _4071_/S vssd1 vssd1 vccd1 vccd1 sky130_fd_sc_hd__diode_2
XFILLER_3_337 vssd1 vssd1 vccd1 vccd1 sky130_fd_sc_hd__fill_2
Xfanout140 fanout141/X vssd1 vssd1 vccd1 vccd1 _4138_/B1 sky130_fd_sc_hd__clkbuf_2
Xfanout162 _4312_/Y vssd1 vssd1 vccd1 vccd1 _4343_/A1 sky130_fd_sc_hd__clkbuf_2
Xfanout173 _3977_/X vssd1 vssd1 vccd1 vccd1 _4036_/A1 sky130_fd_sc_hd__clkbuf_2
Xfanout151 _4338_/A2 vssd1 vssd1 vccd1 vccd1 _4209_/B2 sky130_fd_sc_hd__clkbuf_2
XFILLER_86_182 vccd1 vssd1 vccd1 vssd1 sky130_ef_sc_hd__decap_12
Xfanout195 _2871_/Y vssd1 vssd1 vccd1 vccd1 _2873_/A sky130_fd_sc_hd__clkbuf_2
Xfanout184 _4099_/A0 vssd1 vssd1 vccd1 vccd1 _4103_/A0 sky130_fd_sc_hd__clkbuf_2
XFILLER_63_41 vssd1 vssd1 vccd1 vccd1 sky130_fd_sc_hd__fill_1
XTAP_TAPCELL_ROW_60_729 vssd1 vccd1 sky130_fd_sc_hd__tapvpwrvgnd_1
XFILLER_30_447 vccd1 vssd1 vccd1 vssd1 sky130_ef_sc_hd__decap_12
XFILLER_42_285 vssd1 vssd1 vccd1 vccd1 sky130_fd_sc_hd__fill_2
XANTENNA__2341__S _4036_/S vssd1 vssd1 vccd1 vccd1 sky130_fd_sc_hd__diode_2
X_2320_ _4017_/D _2323_/B _2321_/B2 vssd1 vssd1 vccd1 vccd1 _2320_/Y sky130_fd_sc_hd__o21ai_1
X_2251_ hold53/X _4559_/Q _2272_/S vssd1 vssd1 vccd1 vccd1 _4430_/D sky130_fd_sc_hd__mux2_1
XFILLER_84_108 vccd1 vssd1 vccd1 vssd1 sky130_ef_sc_hd__decap_12
XANTENNA_clkbuf_leaf_23_clk_A clkbuf_2_3__f_clk/X vssd1 vssd1 vccd1 vccd1 sky130_fd_sc_hd__diode_2
XANTENNA__2304__A1 _2304_/A1 vssd1 vssd1 vccd1 vccd1 sky130_fd_sc_hd__diode_2
XFILLER_65_311 vccd1 vssd1 vccd1 vssd1 sky130_ef_sc_hd__decap_12
XANTENNA__4057__A1 _4119_/S vssd1 vssd1 vccd1 vccd1 sky130_fd_sc_hd__diode_2
XTAP_TAPCELL_ROW_76_873 vssd1 vccd1 sky130_fd_sc_hd__tapvpwrvgnd_1
XANTENNA_clkbuf_leaf_38_clk_A clkload2/A vssd1 vssd1 vccd1 vccd1 sky130_fd_sc_hd__diode_2
XFILLER_25_208 vssd1 vssd1 vccd1 vccd1 sky130_fd_sc_hd__decap_8
XFILLER_80_358 vssd1 vssd1 vccd1 vccd1 sky130_fd_sc_hd__decap_6
XFILLER_33_263 vccd1 vssd1 vccd1 vssd1 sky130_ef_sc_hd__decap_12
X_4754_ _4782_/CLK _4754_/D fanout402/X vssd1 vssd1 vccd1 vccd1 _4754_/Q sky130_fd_sc_hd__dfrtp_2
XTAP_TAPCELL_ROW_31_464 vssd1 vccd1 sky130_fd_sc_hd__tapvpwrvgnd_1
X_3705_ _4529_/Q _4638_/Q vssd1 vssd1 vccd1 vccd1 _3705_/Y sky130_fd_sc_hd__nand2_1
X_4685_ _4774_/CLK _4685_/D fanout386/X vssd1 vssd1 vccd1 vccd1 _4685_/Q sky130_fd_sc_hd__dfrtp_1
XANTENNA_fanout113_A _2428_/Y vssd1 vssd1 vccd1 vccd1 sky130_fd_sc_hd__diode_2
X_3636_ _4520_/Q _4629_/Q vssd1 vssd1 vccd1 vccd1 _3643_/B sky130_fd_sc_hd__and2_1
X_3567_ _3566_/Y _3567_/B _4619_/Q _3567_/D vssd1 vssd1 vccd1 vccd1 _3567_/X sky130_fd_sc_hd__and4b_1
X_2518_ _2519_/A _2519_/B _4662_/Q vssd1 vssd1 vccd1 vccd1 _2522_/C sky130_fd_sc_hd__nor3b_1
X_3498_ _3168_/A _3498_/B _3498_/C vssd1 vssd1 vccd1 vccd1 _3498_/Y sky130_fd_sc_hd__nand3b_1
X_2449_ _2442_/Y _2448_/Y _3806_/A2 vssd1 vssd1 vccd1 vccd1 _2449_/Y sky130_fd_sc_hd__o21ai_1
XFILLER_84_29 vccd1 vssd1 vccd1 vssd1 sky130_ef_sc_hd__decap_12
X_4119_ _4167_/A0 _4171_/A1 _4119_/S vssd1 vssd1 vccd1 vccd1 _4119_/X sky130_fd_sc_hd__mux2_1
XTAP_TAPCELL_ROW_39_542 vssd1 vccd1 sky130_fd_sc_hd__tapvpwrvgnd_1
XFILLER_24_230 vccd1 vssd1 vccd1 vssd1 sky130_ef_sc_hd__decap_12
XFILLER_12_469 vssd1 vssd1 vccd1 vccd1 sky130_fd_sc_hd__decap_6
XFILLER_33_55 vssd1 vssd1 vccd1 vccd1 sky130_fd_sc_hd__fill_1
XANTENNA__4220__A1 _4219_/C vssd1 vssd1 vccd1 vccd1 sky130_fd_sc_hd__diode_2
XFILLER_3_167 vssd1 vssd1 vccd1 vccd1 sky130_fd_sc_hd__fill_1
XFILLER_79_436 vccd1 vssd1 vccd1 vssd1 sky130_ef_sc_hd__decap_12
XANTENNA__4287__A1 _4352_/A vssd1 vssd1 vccd1 vccd1 sky130_fd_sc_hd__diode_2
XFILLER_58_52 vssd1 vssd1 vccd1 vccd1 sky130_fd_sc_hd__decap_3
Xhold7 hold7/A vssd1 vssd1 vccd1 vccd1 hold7/X sky130_fd_sc_hd__dlygate4sd3_1
XFILLER_58_85 vssd1 vssd1 vccd1 vccd1 sky130_fd_sc_hd__decap_4
XFILLER_47_355 vccd1 vssd1 vccd1 vssd1 sky130_ef_sc_hd__decap_12
XTAP_TAPCELL_ROW_73_843 vssd1 vccd1 sky130_fd_sc_hd__tapvpwrvgnd_1
XPHY_EDGE_ROW_4_Left_92 vssd1 vssd1 vccd1 vccd1 sky130_fd_sc_hd__decap_3
XFILLER_30_244 vssd1 vssd1 vccd1 vccd1 sky130_fd_sc_hd__fill_1
XFILLER_7_473 vccd1 vssd1 vccd1 vssd1 sky130_ef_sc_hd__decap_12
X_4470_ _4549_/CLK _4470_/D fanout415/X vssd1 vssd1 vccd1 vccd1 hold22/A sky130_fd_sc_hd__dfrtp_1
X_3421_ _3254_/X _3288_/Y _3293_/Y vssd1 vssd1 vccd1 vccd1 _3421_/Y sky130_fd_sc_hd__o21ai_1
X_3352_ _4585_/Q _3384_/A2 _3395_/B1 _3367_/C1 vssd1 vssd1 vccd1 vccd1 _3352_/X sky130_fd_sc_hd__o211a_1
X_2303_ _4063_/S _2323_/B vssd1 vssd1 vccd1 vccd1 _2303_/Y sky130_fd_sc_hd__nor2_1
X_3283_ _4549_/Q _4590_/Q vssd1 vssd1 vccd1 vccd1 _3284_/D sky130_fd_sc_hd__xor2_4
X_2234_ hold36/X _4542_/Q _2242_/S vssd1 vssd1 vccd1 vccd1 _4413_/D sky130_fd_sc_hd__mux2_1
XFILLER_38_300 vssd1 vssd1 vccd1 vccd1 sky130_fd_sc_hd__decap_8
XTAP_TAPCELL_ROW_36_512 vssd1 vccd1 sky130_fd_sc_hd__tapvpwrvgnd_1
XFILLER_61_391 vssd1 vssd1 vccd1 vccd1 sky130_fd_sc_hd__fill_1
X_4806_ _4806_/CLK _4806_/D fanout385/X vssd1 vssd1 vccd1 vccd1 _4806_/Q sky130_fd_sc_hd__dfrtp_1
X_2998_ _2998_/A _2998_/B vssd1 vssd1 vccd1 vccd1 _3000_/C sky130_fd_sc_hd__or2_1
XFILLER_21_266 vccd1 vssd1 vccd1 vssd1 sky130_ef_sc_hd__decap_12
XANTENNA_fanout328_A _2304_/A1 vssd1 vssd1 vccd1 vccd1 sky130_fd_sc_hd__diode_2
XANTENNA__4202__A1 _4210_/A1 vssd1 vssd1 vccd1 vccd1 sky130_fd_sc_hd__diode_2
X_4737_ _4815_/CLK _4737_/D fanout394/X vssd1 vssd1 vccd1 vccd1 _4737_/Q sky130_fd_sc_hd__dfrtp_2
XFILLER_21_299 vssd1 vssd1 vccd1 vccd1 sky130_fd_sc_hd__decap_4
XANTENNA_fanout116_X _3870_/B1 vssd1 vssd1 vccd1 vccd1 sky130_fd_sc_hd__diode_2
X_4668_ _4668_/CLK hold58/X _2229_/B vssd1 vssd1 vccd1 vccd1 hold57/A sky130_fd_sc_hd__dfrtp_1
X_3619_ _3604_/X _3611_/Y _3616_/X _3617_/Y vssd1 vssd1 vccd1 vccd1 _3619_/X sky130_fd_sc_hd__o22a_1
X_4599_ _4667_/CLK _4599_/D fanout412/X vssd1 vssd1 vccd1 vccd1 _4599_/Q sky130_fd_sc_hd__dfrtp_2
XTAP_TAPCELL_ROW_8_259 vssd1 vccd1 sky130_fd_sc_hd__tapvpwrvgnd_1
XFILLER_76_417 vssd1 vssd1 vccd1 vccd1 sky130_fd_sc_hd__decap_3
XFILLER_0_137 vssd1 vssd1 vccd1 vccd1 sky130_fd_sc_hd__decap_3
XFILLER_29_311 vssd1 vssd1 vccd1 vccd1 sky130_fd_sc_hd__fill_1
XTAP_TAPCELL_ROW_87_979 vssd1 vccd1 sky130_fd_sc_hd__tapvpwrvgnd_1
XTAP_TAPCELL_ROW_87_968 vssd1 vccd1 sky130_fd_sc_hd__tapvpwrvgnd_1
XFILLER_29_399 vssd1 vssd1 vccd1 vccd1 sky130_fd_sc_hd__fill_1
XFILLER_44_325 vssd1 vssd1 vccd1 vccd1 sky130_fd_sc_hd__fill_1
XFILLER_71_188 vssd1 vssd1 vccd1 vccd1 sky130_fd_sc_hd__decap_8
XFILLER_5_37 vccd1 vssd1 vccd1 vssd1 sky130_ef_sc_hd__decap_12
XFILLER_5_26 vssd1 vssd1 vccd1 vccd1 sky130_fd_sc_hd__fill_1
XPHY_EDGE_ROW_13_Right_13 vssd1 vssd1 vccd1 vccd1 sky130_fd_sc_hd__decap_3
XFILLER_85_83 vssd1 vssd1 vccd1 vccd1 sky130_fd_sc_hd__fill_1
XFILLER_75_461 vssd1 vssd1 vccd1 vccd1 sky130_fd_sc_hd__decap_4
XFILLER_62_122 vssd1 vssd1 vccd1 vccd1 sky130_fd_sc_hd__decap_4
XFILLER_35_369 vssd1 vssd1 vccd1 vccd1 sky130_fd_sc_hd__fill_2
X_3970_ hold172/X _4138_/B1 _3969_/X vssd1 vssd1 vccd1 vccd1 _4683_/D sky130_fd_sc_hd__o21ba_1
X_2921_ _4762_/Q _4777_/Q _2975_/A vssd1 vssd1 vccd1 vccd1 _2924_/B sky130_fd_sc_hd__a21o_1
XANTENNA__4281__S _4352_/A vssd1 vssd1 vccd1 vccd1 sky130_fd_sc_hd__diode_2
XFILLER_86_3 vccd1 vssd1 vccd1 vssd1 sky130_ef_sc_hd__decap_12
X_2852_ _2806_/A _2806_/B _2806_/C _2814_/A vssd1 vssd1 vccd1 vccd1 _2861_/A sky130_fd_sc_hd__a31o_1
XPHY_EDGE_ROW_22_Right_22 vssd1 vssd1 vccd1 vccd1 sky130_fd_sc_hd__decap_3
X_2783_ _2783_/A _2783_/B vssd1 vssd1 vccd1 vccd1 _2783_/X sky130_fd_sc_hd__or2_1
X_4522_ clkload9/A _4522_/D fanout411/X vssd1 vssd1 vccd1 vccd1 _4522_/Q sky130_fd_sc_hd__dfrtp_1
X_4453_ _4687_/CLK _4453_/D fanout383/X vssd1 vssd1 vccd1 vccd1 _4453_/Q sky130_fd_sc_hd__dfrtp_1
Xhold226 _4721_/Q vssd1 vssd1 vccd1 vccd1 hold226/X sky130_fd_sc_hd__dlygate4sd3_1
XANTENNA__4013__C _4037_/C vssd1 vssd1 vccd1 vccd1 sky130_fd_sc_hd__diode_2
Xhold215 _4540_/Q vssd1 vssd1 vccd1 vccd1 hold215/X sky130_fd_sc_hd__dlygate4sd3_1
Xhold204 _4637_/Q vssd1 vssd1 vccd1 vccd1 hold204/X sky130_fd_sc_hd__dlygate4sd3_1
X_3404_ _3406_/A _3406_/B _3406_/C vssd1 vssd1 vccd1 vccd1 _3404_/Y sky130_fd_sc_hd__o21ai_1
X_4384_ _4063_/S input30/X _4400_/S vssd1 vssd1 vccd1 vccd1 _4793_/D sky130_fd_sc_hd__mux2_1
X_3335_ _3383_/A1 _3334_/X _3383_/B1 vssd1 vssd1 vccd1 vccd1 _3335_/X sky130_fd_sc_hd__a21o_1
XFILLER_85_225 vssd1 vssd1 vccd1 vccd1 sky130_fd_sc_hd__decap_4
X_3266_ _3266_/A _3266_/B _3266_/C vssd1 vssd1 vccd1 vccd1 _3350_/A sky130_fd_sc_hd__and3_1
XPHY_EDGE_ROW_31_Right_31 vssd1 vssd1 vccd1 vccd1 sky130_fd_sc_hd__decap_3
XFILLER_58_417 vssd1 vssd1 vccd1 vccd1 sky130_fd_sc_hd__decap_3
XFILLER_38_130 vssd1 vssd1 vccd1 vccd1 sky130_fd_sc_hd__decap_8
X_2217_ _4467_/Q vssd1 vssd1 vccd1 vccd1 _2771_/B sky130_fd_sc_hd__inv_2
XFILLER_38_141 vccd1 vssd1 vccd1 vssd1 sky130_ef_sc_hd__decap_12
X_3197_ _4562_/Q _4603_/Q vssd1 vssd1 vccd1 vccd1 _3197_/X sky130_fd_sc_hd__or2_2
XANTENNA_fanout278_A _4811_/Q vssd1 vssd1 vccd1 vccd1 sky130_fd_sc_hd__diode_2
XTAP_TAPCELL_ROW_84_949 vssd1 vccd1 sky130_fd_sc_hd__tapvpwrvgnd_1
XANTENNA_fanout233_X _4328_/B vssd1 vssd1 vccd1 vccd1 sky130_fd_sc_hd__diode_2
XPHY_EDGE_ROW_40_Right_40 vssd1 vssd1 vccd1 vccd1 sky130_fd_sc_hd__decap_3
XANTENNA_fanout93_A _4410_/S vssd1 vssd1 vccd1 vccd1 sky130_fd_sc_hd__diode_2
XFILLER_1_435 vssd1 vssd1 vccd1 vccd1 sky130_fd_sc_hd__decap_4
XFILLER_1_446 vssd1 vssd1 vccd1 vccd1 sky130_fd_sc_hd__fill_2
XFILLER_1_457 vccd1 vssd1 vccd1 vssd1 sky130_ef_sc_hd__decap_12
XFILLER_39_87 vssd1 vssd1 vccd1 vccd1 sky130_fd_sc_hd__decap_3
XFILLER_64_409 vssd1 vssd1 vccd1 vccd1 sky130_fd_sc_hd__decap_8
XFILLER_57_461 vccd1 vssd1 vccd1 vssd1 sky130_ef_sc_hd__decap_12
XFILLER_17_325 vssd1 vssd1 vccd1 vccd1 sky130_fd_sc_hd__fill_2
XFILLER_29_196 vssd1 vssd1 vccd1 vccd1 sky130_fd_sc_hd__decap_4
XFILLER_44_122 vccd1 vssd1 vccd1 vssd1 sky130_ef_sc_hd__decap_12
XFILLER_72_464 vssd1 vssd1 vccd1 vccd1 sky130_fd_sc_hd__fill_1
XFILLER_72_475 vssd1 vssd1 vccd1 vccd1 sky130_fd_sc_hd__fill_1
XFILLER_32_317 vssd1 vssd1 vccd1 vccd1 sky130_fd_sc_hd__decap_3
XTAP_TAPCELL_ROW_55_684 vssd1 vccd1 sky130_fd_sc_hd__tapvpwrvgnd_1
XFILLER_9_513 vssd1 vssd1 vccd1 vccd1 sky130_fd_sc_hd__fill_1
XTAP_TAPCELL_ROW_10_275 vssd1 vccd1 sky130_fd_sc_hd__tapvpwrvgnd_1
XFILLER_58_7 vssd1 vssd1 vccd1 vccd1 sky130_fd_sc_hd__fill_1
X_3120_ _4770_/Q _4786_/Q vssd1 vssd1 vccd1 vccd1 _3150_/B sky130_fd_sc_hd__and2_1
XFILLER_67_225 vssd1 vssd1 vccd1 vccd1 sky130_fd_sc_hd__fill_1
X_3051_ _3047_/X _3049_/Y _3025_/A vssd1 vssd1 vccd1 vccd1 _3862_/D sky130_fd_sc_hd__o21ai_4
XFILLER_35_111 vssd1 vssd1 vccd1 vccd1 sky130_fd_sc_hd__fill_1
XTAP_TAPCELL_ROW_81_919 vssd1 vccd1 sky130_fd_sc_hd__tapvpwrvgnd_1
XFILLER_35_133 vssd1 vssd1 vccd1 vccd1 sky130_fd_sc_hd__decap_3
XTAP_TAPCELL_ROW_18_353 vssd1 vccd1 sky130_fd_sc_hd__tapvpwrvgnd_1
XFILLER_50_114 vssd1 vssd1 vccd1 vccd1 sky130_fd_sc_hd__decap_3
X_3953_ _3873_/Y _4017_/D _4075_/S _3899_/Y vssd1 vssd1 vccd1 vccd1 _3953_/Y sky130_fd_sc_hd__o22ai_1
X_2904_ _4763_/Q _4778_/Q vssd1 vssd1 vccd1 vccd1 _2905_/B sky130_fd_sc_hd__nor2_1
X_3884_ _4136_/B _4120_/C _4199_/D vssd1 vssd1 vccd1 vccd1 _3884_/Y sky130_fd_sc_hd__o21ai_1
XANTENNA_clkbuf_0_clk_X clkbuf_0_clk/X vssd1 vssd1 vccd1 vccd1 sky130_fd_sc_hd__diode_2
X_2835_ _2869_/B _4701_/Q vssd1 vssd1 vccd1 vccd1 _2835_/Y sky130_fd_sc_hd__nor2_1
X_2766_ _2767_/C _2767_/A _4729_/Q vssd1 vssd1 vccd1 vccd1 _2766_/X sky130_fd_sc_hd__a21o_1
X_4505_ _4577_/CLK _4505_/D fanout437/X vssd1 vssd1 vccd1 vccd1 hold69/A sky130_fd_sc_hd__dfrtp_1
X_2697_ _2696_/Y _4772_/Q _2753_/A vssd1 vssd1 vccd1 vccd1 _2753_/B sky130_fd_sc_hd__nand3b_1
X_4436_ _4605_/CLK _4436_/D fanout435/X vssd1 vssd1 vccd1 vccd1 hold43/A sky130_fd_sc_hd__dfrtp_1
X_4367_ _4374_/A0 _4374_/A1 _4371_/A vssd1 vssd1 vccd1 vccd1 _4367_/X sky130_fd_sc_hd__mux2_1
XANTENNA__4341__B1 _4376_/A2 vssd1 vssd1 vccd1 vccd1 sky130_fd_sc_hd__diode_2
XFILLER_86_501 vccd1 vssd1 vccd1 vssd1 sky130_ef_sc_hd__decap_12
XANTENNA_fanout395_A fanout398/X vssd1 vssd1 vccd1 vccd1 sky130_fd_sc_hd__diode_2
X_3318_ _4577_/Q _3318_/B vssd1 vssd1 vccd1 vccd1 _3319_/B sky130_fd_sc_hd__or2_1
X_4298_ _4245_/D _4306_/B _4302_/C _4364_/A vssd1 vssd1 vccd1 vccd1 _4298_/X sky130_fd_sc_hd__and4b_1
XFILLER_58_236 vssd1 vssd1 vccd1 vccd1 sky130_fd_sc_hd__fill_2
XFILLER_73_217 vssd1 vssd1 vccd1 vccd1 sky130_fd_sc_hd__fill_1
XANTENNA_fanout183_X _4167_/A0 vssd1 vssd1 vccd1 vccd1 sky130_fd_sc_hd__diode_2
X_3249_ _3393_/A _3242_/A _3242_/B _3246_/Y _3248_/X vssd1 vssd1 vccd1 vccd1 _3249_/Y
+ sky130_fd_sc_hd__a41oi_2
XANTENNA__4186__S _4324_/A vssd1 vssd1 vccd1 vccd1 sky130_fd_sc_hd__diode_2
XFILLER_66_280 vssd1 vssd1 vccd1 vccd1 sky130_fd_sc_hd__fill_2
XFILLER_81_261 vssd1 vssd1 vccd1 vccd1 sky130_fd_sc_hd__decap_6
XFILLER_26_166 vssd1 vssd1 vccd1 vccd1 sky130_fd_sc_hd__decap_3
XFILLER_54_486 vssd1 vssd1 vccd1 vccd1 sky130_fd_sc_hd__decap_4
XFILLER_25_67 vccd1 vssd1 vccd1 vssd1 sky130_ef_sc_hd__decap_12
XFILLER_41_125 vssd1 vssd1 vccd1 vccd1 sky130_fd_sc_hd__fill_2
XTAP_TAPCELL_ROW_52_654 vssd1 vccd1 sky130_fd_sc_hd__tapvpwrvgnd_1
XANTENNA__3922__A3 _2369_/S vssd1 vssd1 vccd1 vccd1 sky130_fd_sc_hd__diode_2
XFILLER_1_276 vssd1 vssd1 vccd1 vccd1 sky130_fd_sc_hd__fill_2
XANTENNA__2343__C1 _3946_/A2 vssd1 vssd1 vccd1 vccd1 sky130_fd_sc_hd__diode_2
XFILLER_2_27 vssd1 vssd1 vccd1 vccd1 sky130_fd_sc_hd__fill_1
XFILLER_49_225 vssd1 vssd1 vccd1 vccd1 sky130_fd_sc_hd__fill_1
XFILLER_66_41 vccd1 vssd1 vccd1 vssd1 sky130_ef_sc_hd__decap_12
XANTENNA__4399__A0 _4001_/B vssd1 vssd1 vccd1 vccd1 sky130_fd_sc_hd__diode_2
XFILLER_17_166 vssd1 vssd1 vccd1 vccd1 sky130_fd_sc_hd__fill_2
XFILLER_82_62 vssd1 vssd1 vccd1 vccd1 sky130_fd_sc_hd__fill_2
XTAP_TAPCELL_ROW_15_323 vssd1 vccd1 sky130_fd_sc_hd__tapvpwrvgnd_1
XFILLER_70_6 vssd1 vssd1 vccd1 vccd1 sky130_fd_sc_hd__fill_1
X_2620_ _2621_/C _2621_/A _2621_/B vssd1 vssd1 vccd1 vccd1 _2622_/A sky130_fd_sc_hd__a21o_1
XFILLER_63_5 vssd1 vssd1 vccd1 vccd1 sky130_fd_sc_hd__decap_8
X_2551_ _2551_/A _2551_/B vssd1 vssd1 vccd1 vccd1 _2552_/B sky130_fd_sc_hd__nor2_1
X_2482_ _2482_/A _2482_/B vssd1 vssd1 vccd1 vccd1 _2483_/B sky130_fd_sc_hd__nor2_1
XANTENNA__2299__B _2323_/B vssd1 vssd1 vccd1 vccd1 sky130_fd_sc_hd__diode_2
XFILLER_87_309 vccd1 vssd1 vccd1 vssd1 sky130_ef_sc_hd__decap_12
XFILLER_49_3 vssd1 vssd1 vccd1 vccd1 sky130_fd_sc_hd__fill_1
X_4221_ _4220_/Y _4219_/X _4218_/X hold136/X _4224_/B1 vssd1 vssd1 vccd1 vccd1 _4747_/D
+ sky130_fd_sc_hd__o32a_1
X_4152_ _4223_/D _4172_/B _4168_/C _4219_/C vssd1 vssd1 vccd1 vccd1 _4152_/X sky130_fd_sc_hd__and4b_1
X_3103_ _3086_/X _3091_/A _3101_/X _3102_/X vssd1 vssd1 vccd1 vccd1 _3103_/X sky130_fd_sc_hd__o211a_1
XFILLER_28_409 vssd1 vssd1 vccd1 vccd1 sky130_fd_sc_hd__fill_2
XANTENNA__3429__A2 _3794_/A0 vssd1 vssd1 vccd1 vccd1 sky130_fd_sc_hd__diode_2
X_4083_ _4103_/A0 _4083_/A1 _4223_/C vssd1 vssd1 vccd1 vccd1 _4083_/X sky130_fd_sc_hd__mux2_1
X_3034_ _3035_/B _3035_/C _3031_/X vssd1 vssd1 vccd1 vccd1 _3036_/A sky130_fd_sc_hd__a21boi_1
XTAP_TAPCELL_ROW_66_779 vssd1 vccd1 sky130_fd_sc_hd__tapvpwrvgnd_1
XFILLER_63_250 vssd1 vssd1 vccd1 vccd1 sky130_fd_sc_hd__fill_1
X_3936_ _3984_/S _3900_/X _3900_/B _4672_/Q vssd1 vssd1 vccd1 vccd1 _3936_/X sky130_fd_sc_hd__a2bb2o_1
XANTENNA_fanout143_A _3922_/B1 vssd1 vssd1 vccd1 vccd1 sky130_fd_sc_hd__diode_2
X_3867_ _3867_/A _3867_/B vssd1 vssd1 vccd1 vccd1 _3868_/B sky130_fd_sc_hd__xnor2_1
XANTENNA_fanout310_A _4798_/Q vssd1 vssd1 vccd1 vccd1 sky130_fd_sc_hd__diode_2
XANTENNA_fanout408_A fanout414/X vssd1 vssd1 vccd1 vccd1 sky130_fd_sc_hd__diode_2
X_3798_ _4651_/Q _3798_/B vssd1 vssd1 vccd1 vccd1 _3798_/X sky130_fd_sc_hd__or2_1
X_2818_ _2771_/B _2771_/A _2769_/Y vssd1 vssd1 vccd1 vccd1 _2820_/A sky130_fd_sc_hd__o21ai_1
X_2749_ _2747_/Y _2749_/B vssd1 vssd1 vccd1 vccd1 _2749_/Y sky130_fd_sc_hd__nand2b_1
XFILLER_87_29 vccd1 vssd1 vccd1 vssd1 sky130_ef_sc_hd__decap_12
Xfanout311 _4798_/Q vssd1 vssd1 vccd1 vccd1 _4356_/A sky130_fd_sc_hd__clkbuf_2
Xfanout322 _2311_/A vssd1 vssd1 vccd1 vccd1 _4344_/A sky130_fd_sc_hd__buf_1
X_4419_ _4553_/CLK _4419_/D fanout419/X vssd1 vssd1 vccd1 vccd1 hold26/A sky130_fd_sc_hd__dfrtp_1
Xfanout300 _4802_/Q vssd1 vssd1 vccd1 vccd1 _4037_/D sky130_fd_sc_hd__buf_2
XANTENNA_fanout398_X fanout398/X vssd1 vssd1 vccd1 vccd1 sky130_fd_sc_hd__diode_2
Xfanout333 _4792_/Q vssd1 vssd1 vccd1 vccd1 _4332_/A sky130_fd_sc_hd__clkbuf_4
Xfanout344 _4789_/Q vssd1 vssd1 vccd1 vccd1 _4320_/A sky130_fd_sc_hd__clkbuf_4
Xfanout355 _4667_/Q vssd1 vssd1 vccd1 vccd1 _4377_/B1 sky130_fd_sc_hd__clkbuf_4
Xfanout366 fanout368/X vssd1 vssd1 vccd1 vccd1 _3477_/B1 sky130_fd_sc_hd__buf_2
Xfanout377 fanout379/X vssd1 vssd1 vccd1 vccd1 fanout377/X sky130_fd_sc_hd__clkbuf_4
Xfanout388 fanout405/X vssd1 vssd1 vccd1 vccd1 fanout388/X sky130_fd_sc_hd__clkbuf_2
Xfanout399 fanout401/X vssd1 vssd1 vccd1 vccd1 fanout399/X sky130_fd_sc_hd__clkbuf_4
XTAP_TAPCELL_ROW_57_702 vssd1 vccd1 sky130_fd_sc_hd__tapvpwrvgnd_1
XTAP_TAPCELL_ROW_29_448 vssd1 vccd1 sky130_fd_sc_hd__tapvpwrvgnd_1
XANTENNA__4093__A2 _4105_/A2 vssd1 vssd1 vccd1 vccd1 sky130_fd_sc_hd__diode_2
XFILLER_42_401 vssd1 vssd1 vccd1 vccd1 sky130_fd_sc_hd__decap_8
XFILLER_54_283 vssd1 vssd1 vccd1 vccd1 sky130_fd_sc_hd__fill_1
XFILLER_14_169 vssd1 vssd1 vccd1 vccd1 sky130_fd_sc_hd__fill_2
Xinput19 s_axis_tdata[24] vssd1 vssd1 vccd1 vccd1 input19/X sky130_fd_sc_hd__clkbuf_1
XFILLER_22_180 vssd1 vssd1 vccd1 vccd1 sky130_fd_sc_hd__decap_4
XTAP_TAPCELL_ROW_20_370 vssd1 vccd1 sky130_fd_sc_hd__tapvpwrvgnd_1
XANTENNA__2564__C1 _2274_/A vssd1 vssd1 vccd1 vccd1 sky130_fd_sc_hd__diode_2
XFILLER_52_209 vssd1 vssd1 vccd1 vccd1 sky130_fd_sc_hd__decap_6
XFILLER_60_253 vssd1 vssd1 vccd1 vccd1 sky130_fd_sc_hd__decap_8
X_4770_ _4818_/CLK _4770_/D fanout397/X vssd1 vssd1 vccd1 vccd1 _4770_/Q sky130_fd_sc_hd__dfrtp_4
XFILLER_60_286 vccd1 vssd1 vccd1 vssd1 sky130_ef_sc_hd__decap_12
X_3721_ _4531_/Q _4640_/Q vssd1 vssd1 vccd1 vccd1 _3743_/A sky130_fd_sc_hd__and2_1
XFILLER_9_162 vssd1 vssd1 vccd1 vccd1 sky130_fd_sc_hd__fill_1
XANTENNA__4005__D _4005_/D vssd1 vssd1 vccd1 vccd1 sky130_fd_sc_hd__diode_2
X_3652_ _4522_/Q _4631_/Q vssd1 vssd1 vccd1 vccd1 _3653_/B sky130_fd_sc_hd__and2_1
X_3583_ _3579_/X _3581_/X _3613_/B _3561_/C vssd1 vssd1 vccd1 vccd1 _3583_/X sky130_fd_sc_hd__o211a_1
X_2603_ hold94/A _4681_/Q vssd1 vssd1 vccd1 vccd1 _2604_/C sky130_fd_sc_hd__nor2_1
X_2534_ _2524_/Y _2534_/B vssd1 vssd1 vccd1 vccd1 _2534_/Y sky130_fd_sc_hd__nand2b_1
XANTENNA__4021__C _4037_/C vssd1 vssd1 vccd1 vccd1 sky130_fd_sc_hd__diode_2
X_2465_ _2465_/A _2465_/B vssd1 vssd1 vccd1 vccd1 _2467_/B sky130_fd_sc_hd__xor2_1
X_4204_ _4203_/C _4212_/A2 _4205_/B2 vssd1 vssd1 vccd1 vccd1 _4204_/Y sky130_fd_sc_hd__o21ai_1
X_2396_ hold44/X _2395_/X _2426_/S vssd1 vssd1 vccd1 vccd1 _4493_/D sky130_fd_sc_hd__mux2_1
XFILLER_68_353 vssd1 vssd1 vccd1 vccd1 sky130_fd_sc_hd__fill_2
XANTENNA__3945__A1_N _4063_/S vssd1 vssd1 vccd1 vccd1 sky130_fd_sc_hd__diode_2
X_4135_ _4171_/A0 _4167_/A1 _4274_/D vssd1 vssd1 vccd1 vccd1 _4135_/X sky130_fd_sc_hd__mux2_1
X_4066_ _4065_/Y _4064_/X _4063_/X hold149/X _4130_/B1 vssd1 vssd1 vccd1 vccd1 _4708_/D
+ sky130_fd_sc_hd__o32a_1
X_3017_ _4767_/Q _4782_/Q vssd1 vssd1 vccd1 vccd1 _3018_/B sky130_fd_sc_hd__nor2_1
XFILLER_36_261 vssd1 vssd1 vccd1 vccd1 sky130_fd_sc_hd__fill_1
XANTENNA_fanout260_A _4815_/Q vssd1 vssd1 vccd1 vccd1 sky130_fd_sc_hd__diode_2
XFILLER_36_272 vssd1 vssd1 vccd1 vccd1 sky130_fd_sc_hd__fill_1
XFILLER_24_467 vssd1 vssd1 vccd1 vccd1 sky130_fd_sc_hd__fill_1
XANTENNA_fanout146_X _3922_/B1 vssd1 vssd1 vccd1 vccd1 sky130_fd_sc_hd__diode_2
XFILLER_51_275 vssd1 vssd1 vccd1 vccd1 sky130_fd_sc_hd__decap_4
X_3919_ _4818_/Q _3919_/B _4371_/C vssd1 vssd1 vccd1 vccd1 _3919_/X sky130_fd_sc_hd__or3_1
XTAP_TAPCELL_ROW_34_495 vssd1 vccd1 sky130_fd_sc_hd__tapvpwrvgnd_1
XANTENNA_fanout313_X _4219_/C vssd1 vssd1 vccd1 vccd1 sky130_fd_sc_hd__diode_2
XFILLER_22_79 vssd1 vssd1 vccd1 vccd1 sky130_fd_sc_hd__fill_1
Xfanout130 _4007_/B2 vssd1 vssd1 vccd1 vccd1 _4058_/B2 sky130_fd_sc_hd__clkbuf_2
Xfanout163 _4312_/Y vssd1 vssd1 vccd1 vccd1 _4374_/A1 sky130_fd_sc_hd__clkbuf_2
Xfanout174 _3919_/X vssd1 vssd1 vccd1 vccd1 _4344_/B sky130_fd_sc_hd__buf_2
Xfanout141 _3922_/B1 vssd1 vssd1 vccd1 vccd1 fanout141/X sky130_fd_sc_hd__dlymetal6s2s_1
Xfanout152 _4334_/A2 vssd1 vssd1 vccd1 vccd1 _4264_/B2 sky130_fd_sc_hd__clkbuf_2
Xfanout196 _2871_/Y vssd1 vssd1 vccd1 vccd1 _3862_/A sky130_fd_sc_hd__dlymetal6s2s_1
Xfanout185 _3882_/X vssd1 vssd1 vccd1 vccd1 _4099_/A0 sky130_fd_sc_hd__buf_2
XFILLER_19_217 vssd1 vssd1 vccd1 vccd1 sky130_fd_sc_hd__fill_1
XFILLER_47_32 vssd1 vssd1 vccd1 vccd1 sky130_fd_sc_hd__decap_6
XFILLER_59_375 vssd1 vssd1 vccd1 vccd1 sky130_fd_sc_hd__decap_3
XFILLER_86_194 vssd1 vssd1 vccd1 vccd1 sky130_fd_sc_hd__fill_2
XFILLER_27_283 vssd1 vssd1 vccd1 vccd1 sky130_fd_sc_hd__decap_8
XPHY_EDGE_ROW_69_Right_69 vssd1 vssd1 vccd1 vccd1 sky130_fd_sc_hd__decap_3
XFILLER_42_253 vccd1 vssd1 vccd1 vssd1 sky130_ef_sc_hd__decap_12
XPHY_EDGE_ROW_78_Right_78 vssd1 vssd1 vccd1 vccd1 sky130_fd_sc_hd__decap_3
X_2250_ hold64/X _4558_/Q _2250_/S vssd1 vssd1 vccd1 vccd1 _4429_/D sky130_fd_sc_hd__mux2_1
XFILLER_77_161 vssd1 vssd1 vccd1 vccd1 sky130_fd_sc_hd__decap_6
XFILLER_65_323 vssd1 vssd1 vccd1 vccd1 sky130_fd_sc_hd__fill_2
XFILLER_65_334 vssd1 vssd1 vccd1 vccd1 sky130_fd_sc_hd__fill_2
XANTENNA__4057__A2 _4081_/A2 vssd1 vssd1 vccd1 vccd1 sky130_fd_sc_hd__diode_2
XTAP_TAPCELL_ROW_76_874 vssd1 vccd1 sky130_fd_sc_hd__tapvpwrvgnd_1
XPHY_EDGE_ROW_87_Right_87 vssd1 vssd1 vccd1 vccd1 sky130_fd_sc_hd__decap_3
XFILLER_33_275 vssd1 vssd1 vccd1 vccd1 sky130_fd_sc_hd__decap_4
X_4753_ _4817_/CLK _4753_/D fanout396/X vssd1 vssd1 vccd1 vccd1 _4753_/Q sky130_fd_sc_hd__dfrtp_2
XTAP_TAPCELL_ROW_31_465 vssd1 vccd1 sky130_fd_sc_hd__tapvpwrvgnd_1
X_3704_ _4603_/Q _3549_/A _3703_/Y vssd1 vssd1 vccd1 vccd1 _4603_/D sky130_fd_sc_hd__o21a_1
X_4684_ _4686_/CLK _4684_/D fanout386/X vssd1 vssd1 vccd1 vccd1 _4684_/Q sky130_fd_sc_hd__dfrtp_1
X_3635_ _4520_/Q _4629_/Q vssd1 vssd1 vccd1 vccd1 _3643_/A sky130_fd_sc_hd__nor2_1
X_3566_ _4511_/Q _4620_/Q vssd1 vssd1 vccd1 vccd1 _3566_/Y sky130_fd_sc_hd__nor2_1
X_3497_ _3487_/A _3487_/B _3173_/X vssd1 vssd1 vccd1 vccd1 _3498_/C sky130_fd_sc_hd__a21o_1
X_2517_ _2516_/C _2516_/A _2516_/B vssd1 vssd1 vccd1 vccd1 _2519_/B sky130_fd_sc_hd__o21a_1
X_2448_ _4652_/Q _2448_/B vssd1 vssd1 vccd1 vccd1 _2448_/Y sky130_fd_sc_hd__xnor2_1
X_2379_ _4557_/Q hold10/A _2381_/S vssd1 vssd1 vccd1 vccd1 _2379_/X sky130_fd_sc_hd__mux2_1
X_4118_ _4115_/X _4116_/X _4117_/Y _4122_/B1 hold226/X vssd1 vssd1 vccd1 vccd1 _4721_/D
+ sky130_fd_sc_hd__o32a_1
XTAP_TAPCELL_ROW_39_543 vssd1 vccd1 sky130_fd_sc_hd__tapvpwrvgnd_1
XFILLER_56_334 vssd1 vssd1 vccd1 vccd1 sky130_fd_sc_hd__fill_1
X_4049_ _4116_/B _4081_/A2 _4058_/B2 vssd1 vssd1 vccd1 vccd1 _4049_/Y sky130_fd_sc_hd__o21ai_1
XANTENNA__4194__S _4266_/D vssd1 vssd1 vccd1 vccd1 sky130_fd_sc_hd__diode_2
XFILLER_44_518 vssd1 vssd1 vccd1 vccd1 sky130_fd_sc_hd__fill_1
XFILLER_71_337 vccd1 vssd1 vccd1 vssd1 sky130_ef_sc_hd__decap_12
XFILLER_17_57 vssd1 vssd1 vccd1 vccd1 sky130_fd_sc_hd__decap_6
XFILLER_24_242 vssd1 vssd1 vccd1 vccd1 sky130_fd_sc_hd__decap_8
XFILLER_24_253 vssd1 vssd1 vccd1 vccd1 sky130_fd_sc_hd__decap_6
XANTENNA__4207__B _4211_/B vssd1 vssd1 vccd1 vccd1 sky130_fd_sc_hd__diode_2
XFILLER_8_408 vccd1 vssd1 vccd1 vssd1 sky130_ef_sc_hd__decap_12
XANTENNA__4557__RESET_B fanout423/X vssd1 vssd1 vccd1 vccd1 sky130_fd_sc_hd__diode_2
XFILLER_3_113 vccd1 vssd1 vccd1 vssd1 sky130_ef_sc_hd__decap_12
XANTENNA__4666__Q _4666_/Q vssd1 vssd1 vccd1 vccd1 sky130_fd_sc_hd__diode_2
Xhold8 hold8/A vssd1 vssd1 vccd1 vccd1 hold8/X sky130_fd_sc_hd__dlygate4sd3_1
XANTENNA__2298__A1 _2310_/A1 vssd1 vssd1 vccd1 vccd1 sky130_fd_sc_hd__diode_2
XANTENNA_input36_A s_axis_tvalid vssd1 vssd1 vccd1 vccd1 sky130_fd_sc_hd__diode_2
XFILLER_47_367 vssd1 vssd1 vccd1 vccd1 sky130_fd_sc_hd__decap_4
XFILLER_74_85 vccd1 vssd1 vccd1 vssd1 sky130_ef_sc_hd__decap_12
XTAP_TAPCELL_ROW_73_844 vssd1 vccd1 sky130_fd_sc_hd__tapvpwrvgnd_1
XFILLER_62_337 vssd1 vssd1 vccd1 vccd1 sky130_fd_sc_hd__fill_1
XANTENNA__2352__S _2366_/S vssd1 vssd1 vccd1 vccd1 sky130_fd_sc_hd__diode_2
XFILLER_7_485 vccd1 vssd1 vccd1 vssd1 sky130_ef_sc_hd__decap_12
X_3420_ _4556_/Q _3425_/A2 _3418_/X _3419_/X vssd1 vssd1 vccd1 vccd1 _4556_/D sky130_fd_sc_hd__a22o_1
X_3351_ _3383_/A1 _3350_/Y _3383_/B1 vssd1 vssd1 vccd1 vccd1 _3351_/X sky130_fd_sc_hd__a21o_1
X_2302_ _3875_/A0 _2310_/A1 _4005_/D vssd1 vssd1 vccd1 vccd1 _2302_/X sky130_fd_sc_hd__mux2_1
XFILLER_31_3 vssd1 vssd1 vccd1 vccd1 sky130_fd_sc_hd__fill_1
X_3282_ _3282_/A _4589_/Q vssd1 vssd1 vccd1 vccd1 _3370_/D sky130_fd_sc_hd__or2_2
X_2233_ hold61/X _4541_/Q _2242_/S vssd1 vssd1 vccd1 vccd1 _4412_/D sky130_fd_sc_hd__mux2_1
XTAP_TAPCELL_ROW_36_513 vssd1 vccd1 sky130_fd_sc_hd__tapvpwrvgnd_1
XFILLER_53_326 vssd1 vssd1 vccd1 vccd1 sky130_fd_sc_hd__decap_6
XFILLER_53_337 vssd1 vssd1 vccd1 vccd1 sky130_fd_sc_hd__fill_2
XFILLER_0_93 vssd1 vssd1 vccd1 vccd1 sky130_fd_sc_hd__fill_1
X_4805_ _4806_/CLK _4805_/D fanout383/X vssd1 vssd1 vccd1 vccd1 _4805_/Q sky130_fd_sc_hd__dfrtp_1
XANTENNA__2262__S _2270_/S vssd1 vssd1 vccd1 vccd1 sky130_fd_sc_hd__diode_2
X_2997_ _2988_/Y _2989_/X _2995_/Y vssd1 vssd1 vccd1 vccd1 _2998_/B sky130_fd_sc_hd__o21a_1
XFILLER_21_278 vssd1 vssd1 vccd1 vccd1 sky130_fd_sc_hd__fill_2
X_4736_ _4751_/CLK _4736_/D fanout396/X vssd1 vssd1 vccd1 vccd1 _4736_/Q sky130_fd_sc_hd__dfrtp_4
X_4667_ _4667_/CLK _4667_/D fanout412/X vssd1 vssd1 vccd1 vccd1 _4667_/Q sky130_fd_sc_hd__dfrtp_1
X_3618_ _4517_/Q _4626_/Q _3611_/Y _3616_/X _3617_/Y vssd1 vssd1 vccd1 vccd1 _3618_/Y
+ sky130_fd_sc_hd__a2111oi_1
X_4598_ _4667_/CLK _4598_/D fanout412/X vssd1 vssd1 vccd1 vccd1 _4598_/Q sky130_fd_sc_hd__dfrtp_2
X_3549_ _3549_/A _3558_/A _3549_/C vssd1 vssd1 vccd1 vccd1 _3549_/X sky130_fd_sc_hd__and3_1
XTAP_TAPCELL_ROW_87_969 vssd1 vccd1 sky130_fd_sc_hd__tapvpwrvgnd_1
XFILLER_29_378 vssd1 vssd1 vccd1 vccd1 sky130_fd_sc_hd__fill_1
XANTENNA__4738__RESET_B fanout382/X vssd1 vssd1 vccd1 vccd1 sky130_fd_sc_hd__diode_2
XFILLER_12_201 vccd1 vssd1 vccd1 vssd1 sky130_ef_sc_hd__decap_12
XANTENNA_clkbuf_leaf_22_clk_A clkbuf_2_3__f_clk/X vssd1 vssd1 vccd1 vccd1 sky130_fd_sc_hd__diode_2
XFILLER_12_278 vccd1 vssd1 vccd1 vssd1 sky130_ef_sc_hd__decap_12
XFILLER_5_49 vssd1 vssd1 vccd1 vccd1 sky130_fd_sc_hd__decap_6
XFILLER_4_477 vccd1 vssd1 vccd1 vssd1 sky130_ef_sc_hd__decap_12
XANTENNA_clkbuf_leaf_37_clk_A clkload2/A vssd1 vssd1 vccd1 vccd1 sky130_fd_sc_hd__diode_2
XANTENNA__4099__S _4372_/A vssd1 vssd1 vccd1 vccd1 sky130_fd_sc_hd__diode_2
XFILLER_67_407 vssd1 vssd1 vccd1 vccd1 sky130_fd_sc_hd__decap_6
XFILLER_85_51 vssd1 vssd1 vccd1 vccd1 sky130_fd_sc_hd__decap_4
Xclkbuf_2_3__f_clk clkbuf_0_clk/X vssd1 vssd1 vccd1 vccd1 clkbuf_2_3__f_clk/X sky130_fd_sc_hd__clkbuf_16
XANTENNA__2347__S _2365_/S vssd1 vssd1 vccd1 vccd1 sky130_fd_sc_hd__diode_2
XFILLER_35_337 vccd1 vssd1 vccd1 vssd1 sky130_ef_sc_hd__decap_12
XANTENNA_clkload1_A clkload1/A vssd1 vssd1 vccd1 vccd1 sky130_fd_sc_hd__diode_2
X_2920_ _2872_/A _2868_/Y _2871_/C vssd1 vssd1 vccd1 vccd1 _2920_/Y sky130_fd_sc_hd__o21ai_1
XTAP_TAPCELL_ROW_41_560 vssd1 vccd1 sky130_fd_sc_hd__tapvpwrvgnd_1
XANTENNA__4196__A1 _4323_/S vssd1 vssd1 vccd1 vccd1 sky130_fd_sc_hd__diode_2
X_2851_ _2849_/Y _2851_/B vssd1 vssd1 vccd1 vccd1 _2851_/Y sky130_fd_sc_hd__nand2b_1
X_2782_ _2782_/A _2782_/B vssd1 vssd1 vccd1 vccd1 _2783_/B sky130_fd_sc_hd__and2_1
XFILLER_7_260 vssd1 vssd1 vccd1 vccd1 sky130_fd_sc_hd__fill_1
XANTENNA__3943__A1 _3946_/A1 vssd1 vssd1 vccd1 vccd1 sky130_fd_sc_hd__diode_2
X_4521_ _4631_/CLK _4521_/D fanout411/X vssd1 vssd1 vccd1 vccd1 _4521_/Q sky130_fd_sc_hd__dfrtp_1
Xhold216 _4647_/Q vssd1 vssd1 vccd1 vccd1 hold216/X sky130_fd_sc_hd__dlygate4sd3_1
X_4452_ _4687_/CLK _4452_/D fanout383/X vssd1 vssd1 vccd1 vccd1 _4452_/Q sky130_fd_sc_hd__dfrtp_1
Xhold205 _4466_/Q vssd1 vssd1 vccd1 vccd1 hold205/X sky130_fd_sc_hd__dlygate4sd3_1
XANTENNA__4013__D _4075_/S vssd1 vssd1 vccd1 vccd1 sky130_fd_sc_hd__diode_2
Xhold227 _4764_/Q vssd1 vssd1 vccd1 vccd1 hold227/X sky130_fd_sc_hd__dlygate4sd3_1
X_3403_ _3398_/A _3398_/B _3228_/Y vssd1 vssd1 vccd1 vccd1 _3403_/Y sky130_fd_sc_hd__o21ai_1
X_4383_ _4064_/D input29/X _4400_/S vssd1 vssd1 vccd1 vccd1 _4792_/D sky130_fd_sc_hd__mux2_1
X_3334_ _4541_/Q _4582_/Q vssd1 vssd1 vccd1 vccd1 _3334_/X sky130_fd_sc_hd__xor2_1
X_3265_ _3338_/A _3264_/Y _3261_/Y vssd1 vssd1 vccd1 vccd1 _3266_/A sky130_fd_sc_hd__o21ai_2
X_2216_ hold78/A vssd1 vssd1 vccd1 vccd1 _2845_/B sky130_fd_sc_hd__inv_2
XFILLER_38_153 vccd1 vssd1 vccd1 vssd1 sky130_ef_sc_hd__decap_12
X_3196_ _3458_/B _3203_/B vssd1 vssd1 vccd1 vccd1 _3295_/A sky130_fd_sc_hd__and2_1
XFILLER_81_421 vssd1 vssd1 vccd1 vccd1 sky130_fd_sc_hd__fill_2
XANTENNA__3877__A _4808_/Q vssd1 vssd1 vccd1 vccd1 sky130_fd_sc_hd__diode_2
XANTENNA_fanout340_A _4253_/S vssd1 vssd1 vccd1 vccd1 sky130_fd_sc_hd__diode_2
XFILLER_14_69 vccd1 vssd1 vccd1 vssd1 sky130_ef_sc_hd__decap_12
XANTENNA_fanout226_X _4176_/A2 vssd1 vssd1 vccd1 vccd1 sky130_fd_sc_hd__diode_2
X_4719_ _4751_/CLK _4719_/D fanout396/X vssd1 vssd1 vccd1 vccd1 _4719_/Q sky130_fd_sc_hd__dfrtp_1
XPHY_EDGE_ROW_15_Left_103 vssd1 vssd1 vccd1 vccd1 sky130_fd_sc_hd__decap_3
XFILLER_5_219 vssd1 vssd1 vccd1 vccd1 sky130_fd_sc_hd__fill_1
XANTENNA__3934__A1 _2274_/B vssd1 vssd1 vccd1 vccd1 sky130_fd_sc_hd__diode_2
XANTENNA_fanout86_A _3460_/B1 vssd1 vssd1 vccd1 vccd1 sky130_fd_sc_hd__diode_2
XFILLER_1_469 vccd1 vssd1 vccd1 vssd1 sky130_ef_sc_hd__decap_12
XPHY_EDGE_ROW_24_Left_112 vssd1 vssd1 vccd1 vccd1 sky130_fd_sc_hd__decap_3
XTAP_TAPCELL_ROW_47_608 vssd1 vccd1 sky130_fd_sc_hd__tapvpwrvgnd_1
XFILLER_84_281 vssd1 vssd1 vccd1 vccd1 sky130_fd_sc_hd__decap_8
XANTENNA__3870__B1 _3870_/B1 vssd1 vssd1 vccd1 vccd1 sky130_fd_sc_hd__diode_2
XFILLER_57_473 vssd1 vssd1 vccd1 vccd1 sky130_fd_sc_hd__decap_3
XFILLER_72_443 vccd1 vssd1 vccd1 vssd1 sky130_ef_sc_hd__decap_12
XFILLER_17_348 vssd1 vssd1 vccd1 vccd1 sky130_fd_sc_hd__decap_3
XFILLER_44_134 vssd1 vssd1 vccd1 vccd1 sky130_fd_sc_hd__decap_6
XFILLER_44_156 vccd1 vssd1 vccd1 vssd1 sky130_ef_sc_hd__decap_12
XTAP_TAPCELL_ROW_55_685 vssd1 vccd1 sky130_fd_sc_hd__tapvpwrvgnd_1
XFILLER_9_503 vssd1 vssd1 vccd1 vccd1 sky130_fd_sc_hd__fill_1
XPHY_EDGE_ROW_33_Left_121 vssd1 vssd1 vccd1 vccd1 sky130_fd_sc_hd__decap_3
XTAP_TAPCELL_ROW_10_276 vssd1 vccd1 sky130_fd_sc_hd__tapvpwrvgnd_1
XPHY_EDGE_ROW_42_Left_130 vssd1 vssd1 vccd1 vccd1 sky130_fd_sc_hd__decap_3
X_3050_ _3049_/Y _4736_/Q _3050_/C vssd1 vssd1 vccd1 vccd1 _3862_/C sky130_fd_sc_hd__nand3b_4
XFILLER_63_465 vssd1 vssd1 vccd1 vccd1 sky130_fd_sc_hd__fill_1
XTAP_TAPCELL_ROW_18_354 vssd1 vccd1 sky130_fd_sc_hd__tapvpwrvgnd_1
XFILLER_23_318 vssd1 vssd1 vccd1 vccd1 sky130_fd_sc_hd__decap_8
X_3952_ hold168/X _3995_/B2 _3951_/X vssd1 vssd1 vccd1 vccd1 _4677_/D sky130_fd_sc_hd__o21a_1
X_2903_ _4763_/Q _4778_/Q vssd1 vssd1 vccd1 vccd1 _2949_/B sky130_fd_sc_hd__and2_1
X_3883_ _4099_/A0 hold125/X _3886_/S vssd1 vssd1 vccd1 vccd1 _4653_/D sky130_fd_sc_hd__mux2_1
X_2834_ _2869_/B _4701_/Q vssd1 vssd1 vccd1 vccd1 _2836_/C sky130_fd_sc_hd__nand2_1
X_4504_ _4577_/CLK _4504_/D fanout438/X vssd1 vssd1 vccd1 vccd1 hold68/A sky130_fd_sc_hd__dfrtp_1
X_2765_ _4744_/Q _4714_/Q vssd1 vssd1 vccd1 vccd1 _2767_/A sky130_fd_sc_hd__or2_1
X_2696_ _4665_/Q _4757_/Q vssd1 vssd1 vccd1 vccd1 _2696_/Y sky130_fd_sc_hd__nor2_1
X_4435_ _4605_/CLK _4435_/D fanout435/X vssd1 vssd1 vccd1 vccd1 hold46/A sky130_fd_sc_hd__dfrtp_1
X_4366_ _4365_/Y _4364_/X _4363_/X _4784_/Q _4378_/B2 vssd1 vssd1 vccd1 vccd1 _4784_/D
+ sky130_fd_sc_hd__o32a_1
XANTENNA__4341__A1 _4340_/A vssd1 vssd1 vccd1 vccd1 sky130_fd_sc_hd__diode_2
XFILLER_86_513 vssd1 vssd1 vccd1 vccd1 sky130_fd_sc_hd__decap_6
X_3317_ _4577_/Q _3318_/B vssd1 vssd1 vccd1 vccd1 _3531_/A sky130_fd_sc_hd__nand2_1
X_4297_ _4305_/A0 _4305_/A1 _4368_/A vssd1 vssd1 vccd1 vccd1 _4297_/X sky130_fd_sc_hd__mux2_1
XANTENNA_fanout290_A _4808_/Q vssd1 vssd1 vccd1 vccd1 sky130_fd_sc_hd__diode_2
XANTENNA_fanout388_A fanout405/X vssd1 vssd1 vccd1 vccd1 sky130_fd_sc_hd__diode_2
XTAP_TAPCELL_ROW_1_200 vssd1 vccd1 sky130_fd_sc_hd__tapvpwrvgnd_1
X_3248_ _4552_/Q _4593_/Q _3247_/X vssd1 vssd1 vccd1 vccd1 _3248_/X sky130_fd_sc_hd__o21a_1
X_3179_ _4567_/Q _4608_/Q vssd1 vssd1 vccd1 vccd1 _3475_/A sky130_fd_sc_hd__and2_1
XFILLER_54_421 vssd1 vssd1 vccd1 vccd1 sky130_fd_sc_hd__decap_8
XFILLER_22_340 vccd1 vssd1 vccd1 vssd1 sky130_ef_sc_hd__decap_12
XTAP_TAPCELL_ROW_52_655 vssd1 vccd1 sky130_fd_sc_hd__tapvpwrvgnd_1
XFILLER_9_3 vssd1 vssd1 vccd1 vccd1 sky130_fd_sc_hd__fill_1
XANTENNA__2343__B1 _3946_/A1 vssd1 vssd1 vccd1 vccd1 sky130_fd_sc_hd__diode_2
XFILLER_66_53 vssd1 vssd1 vccd1 vccd1 sky130_fd_sc_hd__fill_2
XFILLER_82_41 vssd1 vssd1 vccd1 vccd1 sky130_fd_sc_hd__decap_3
XTAP_TAPCELL_ROW_15_324 vssd1 vccd1 sky130_fd_sc_hd__tapvpwrvgnd_1
XANTENNA__2360__S _2366_/S vssd1 vssd1 vccd1 vccd1 sky130_fd_sc_hd__diode_2
XANTENNA__4020__A0 _4020_/A0 vssd1 vssd1 vccd1 vccd1 sky130_fd_sc_hd__diode_2
X_2550_ _2549_/A _2549_/B _4655_/Q vssd1 vssd1 vccd1 vccd1 _2551_/B sky130_fd_sc_hd__o21ba_1
X_2481_ _4661_/Q _2481_/B vssd1 vssd1 vccd1 vccd1 _2482_/B sky130_fd_sc_hd__nor2_1
X_4220_ _4219_/C _4240_/A2 _4224_/B1 vssd1 vssd1 vccd1 vccd1 _4220_/Y sky130_fd_sc_hd__o21ai_1
X_4151_ _4171_/A0 _4167_/A1 _4223_/C vssd1 vssd1 vccd1 vccd1 _4151_/X sky130_fd_sc_hd__mux2_1
XFILLER_83_505 vccd1 vssd1 vccd1 vssd1 sky130_ef_sc_hd__decap_12
X_3102_ _3862_/C _3862_/D _3100_/Y vssd1 vssd1 vccd1 vccd1 _3102_/X sky130_fd_sc_hd__a21o_1
X_4082_ _4081_/Y _4080_/X _4079_/X hold99/X _4205_/B2 vssd1 vssd1 vccd1 vccd1 _4712_/D
+ sky130_fd_sc_hd__o32a_1
X_3033_ _3033_/A _3033_/B vssd1 vssd1 vccd1 vccd1 _3035_/C sky130_fd_sc_hd__nand2_1
XANTENNA__4316__A _4316_/A vssd1 vssd1 vccd1 vccd1 sky130_fd_sc_hd__diode_2
X_3935_ _3872_/X _3971_/A1 _3935_/S vssd1 vssd1 vccd1 vccd1 _3935_/X sky130_fd_sc_hd__mux2_1
XFILLER_23_159 vssd1 vssd1 vccd1 vccd1 sky130_fd_sc_hd__fill_1
X_3866_ _3866_/A _3866_/B vssd1 vssd1 vccd1 vccd1 _3867_/B sky130_fd_sc_hd__xnor2_1
XFILLER_31_192 vssd1 vssd1 vccd1 vccd1 sky130_fd_sc_hd__fill_1
X_3797_ _3796_/Y _2430_/X _3795_/S hold135/X vssd1 vssd1 vccd1 vccd1 _4617_/D sky130_fd_sc_hd__a2bb2o_1
X_2817_ _2766_/X _2767_/Y _2777_/Y _2775_/Y vssd1 vssd1 vccd1 vccd1 _2828_/B sky130_fd_sc_hd__a31o_1
XANTENNA__2270__S _2270_/S vssd1 vssd1 vccd1 vccd1 sky130_fd_sc_hd__diode_2
XANTENNA_fanout303_A _4801_/Q vssd1 vssd1 vccd1 vccd1 sky130_fd_sc_hd__diode_2
X_2748_ _2748_/A _2748_/B vssd1 vssd1 vccd1 vccd1 _2749_/B sky130_fd_sc_hd__nand2_1
X_4418_ _4546_/CLK _4418_/D fanout417/X vssd1 vssd1 vccd1 vccd1 hold35/A sky130_fd_sc_hd__dfrtp_1
X_2679_ _2679_/A _4755_/Q _4664_/Q vssd1 vssd1 vccd1 vccd1 _2682_/B sky130_fd_sc_hd__nand3_1
Xfanout301 _4368_/A vssd1 vssd1 vccd1 vccd1 _4302_/D sky130_fd_sc_hd__buf_2
Xfanout323 _4795_/Q vssd1 vssd1 vccd1 vccd1 _2311_/A sky130_fd_sc_hd__buf_2
Xfanout312 _4798_/Q vssd1 vssd1 vccd1 vccd1 _4021_/D sky130_fd_sc_hd__buf_2
X_4349_ _4348_/A _4372_/B _4358_/A2 vssd1 vssd1 vccd1 vccd1 _4349_/Y sky130_fd_sc_hd__o21ai_1
Xfanout334 _4328_/A vssd1 vssd1 vccd1 vccd1 _4123_/S sky130_fd_sc_hd__clkbuf_4
Xfanout345 _4316_/A vssd1 vssd1 vccd1 vccd1 _4116_/B sky130_fd_sc_hd__clkbuf_2
XANTENNA_fanout293_X _4033_/C vssd1 vssd1 vccd1 vccd1 sky130_fd_sc_hd__diode_2
Xfanout356 _4648_/Q vssd1 vssd1 vccd1 vccd1 _3613_/B sky130_fd_sc_hd__buf_2
XFILLER_86_365 vccd1 vssd1 vccd1 vssd1 sky130_ef_sc_hd__decap_12
Xfanout367 fanout368/X vssd1 vssd1 vccd1 vccd1 _3504_/B1 sky130_fd_sc_hd__clkbuf_2
Xfanout378 fanout379/X vssd1 vssd1 vccd1 vccd1 fanout378/X sky130_fd_sc_hd__clkbuf_2
Xfanout389 fanout393/X vssd1 vssd1 vccd1 vccd1 fanout389/X sky130_fd_sc_hd__clkbuf_4
XTAP_TAPCELL_ROW_57_703 vssd1 vccd1 sky130_fd_sc_hd__tapvpwrvgnd_1
XTAP_TAPCELL_ROW_29_449 vssd1 vccd1 sky130_fd_sc_hd__tapvpwrvgnd_1
XFILLER_36_23 vssd1 vssd1 vccd1 vccd1 sky130_fd_sc_hd__fill_1
XFILLER_54_251 vssd1 vssd1 vccd1 vccd1 sky130_fd_sc_hd__fill_1
XFILLER_52_11 vssd1 vssd1 vccd1 vccd1 sky130_fd_sc_hd__decap_3
XFILLER_52_55 vssd1 vssd1 vccd1 vccd1 sky130_fd_sc_hd__fill_1
XFILLER_10_321 vccd1 vssd1 vccd1 vssd1 sky130_ef_sc_hd__decap_12
XFILLER_10_365 vssd1 vssd1 vccd1 vccd1 sky130_fd_sc_hd__fill_2
XFILLER_6_369 vssd1 vssd1 vccd1 vccd1 sky130_fd_sc_hd__fill_1
XTAP_TAPCELL_ROW_20_371 vssd1 vccd1 sky130_fd_sc_hd__tapvpwrvgnd_1
XANTENNA__2564__B1 _4666_/Q vssd1 vssd1 vccd1 vccd1 sky130_fd_sc_hd__diode_2
XANTENNA__2316__B1 _3890_/S vssd1 vssd1 vccd1 vccd1 sky130_fd_sc_hd__diode_2
XFILLER_77_41 vccd1 vssd1 vccd1 vssd1 sky130_ef_sc_hd__decap_12
XFILLER_65_505 vssd1 vssd1 vccd1 vccd1 sky130_fd_sc_hd__fill_1
XFILLER_28_9 vssd1 vssd1 vccd1 vccd1 sky130_fd_sc_hd__fill_2
XFILLER_37_229 vssd1 vssd1 vccd1 vccd1 sky130_fd_sc_hd__fill_1
XFILLER_80_508 vssd1 vssd1 vccd1 vccd1 sky130_fd_sc_hd__decap_3
XFILLER_18_421 vccd1 vssd1 vccd1 vssd1 sky130_ef_sc_hd__decap_12
XANTENNA__2355__S _2365_/S vssd1 vssd1 vccd1 vccd1 sky130_fd_sc_hd__diode_2
XFILLER_60_221 vssd1 vssd1 vccd1 vccd1 sky130_fd_sc_hd__decap_8
XFILLER_20_118 vssd1 vssd1 vccd1 vccd1 sky130_fd_sc_hd__decap_6
X_3720_ _3718_/X _3549_/A _3717_/Y _3719_/X vssd1 vssd1 vccd1 vccd1 _4605_/D sky130_fd_sc_hd__a31o_1
XFILLER_60_298 vssd1 vssd1 vccd1 vccd1 sky130_fd_sc_hd__decap_8
XFILLER_13_192 vssd1 vssd1 vccd1 vccd1 sky130_fd_sc_hd__decap_6
Xclkbuf_leaf_40_clk clkload2/A vssd1 vssd1 vccd1 vccd1 _4587_/CLK sky130_fd_sc_hd__clkbuf_8
X_3651_ _4522_/Q _4631_/Q vssd1 vssd1 vccd1 vccd1 _3653_/A sky130_fd_sc_hd__nor2_1
X_3582_ _4512_/Q _4621_/Q _3579_/X _3580_/Y vssd1 vssd1 vccd1 vccd1 _3582_/Y sky130_fd_sc_hd__o211ai_4
XFILLER_9_196 vssd1 vssd1 vccd1 vccd1 sky130_fd_sc_hd__decap_4
X_2602_ hold94/A _4681_/Q vssd1 vssd1 vccd1 vccd1 _2604_/B sky130_fd_sc_hd__and2_1
XFILLER_61_3 vssd1 vssd1 vccd1 vccd1 sky130_fd_sc_hd__decap_4
X_2533_ _2533_/A _2533_/B vssd1 vssd1 vccd1 vccd1 _2534_/B sky130_fd_sc_hd__nand2_1
X_2464_ _4456_/Q _2464_/B vssd1 vssd1 vccd1 vccd1 _2465_/B sky130_fd_sc_hd__xnor2_1
XANTENNA__3504__C1 _3543_/A vssd1 vssd1 vccd1 vccd1 sky130_fd_sc_hd__diode_2
X_4203_ _4258_/C _4211_/B _4203_/C _4239_/D vssd1 vssd1 vccd1 vccd1 _4203_/X sky130_fd_sc_hd__and4b_1
X_2395_ _4565_/Q hold43/A _2419_/S vssd1 vssd1 vccd1 vccd1 _2395_/X sky130_fd_sc_hd__mux2_1
X_4134_ _4131_/X _4132_/X _4133_/Y _4193_/B2 _4725_/Q vssd1 vssd1 vccd1 vccd1 _4725_/D
+ sky130_fd_sc_hd__o32a_1
X_4065_ _4064_/D _4081_/A2 _4130_/B1 vssd1 vssd1 vccd1 vccd1 _4065_/Y sky130_fd_sc_hd__o21ai_1
X_3016_ _4767_/Q _4782_/Q vssd1 vssd1 vccd1 vccd1 _3061_/B sky130_fd_sc_hd__and2_1
XANTENNA__4124__A_N _4199_/D vssd1 vssd1 vccd1 vccd1 sky130_fd_sc_hd__diode_2
XTAP_TAPCELL_ROW_26_419 vssd1 vccd1 sky130_fd_sc_hd__tapvpwrvgnd_1
XANTENNA__2265__S _2270_/S vssd1 vssd1 vccd1 vccd1 sky130_fd_sc_hd__diode_2
XTAP_TAPCELL_ROW_62_750 vssd1 vccd1 sky130_fd_sc_hd__tapvpwrvgnd_1
XFILLER_51_232 vssd1 vssd1 vccd1 vccd1 sky130_fd_sc_hd__fill_1
XTAP_TAPCELL_ROW_34_496 vssd1 vccd1 sky130_fd_sc_hd__tapvpwrvgnd_1
X_3918_ _4264_/B2 _4279_/A2 _3917_/Y vssd1 vssd1 vccd1 vccd1 _4664_/D sky130_fd_sc_hd__a21oi_1
Xclkbuf_leaf_31_clk clkbuf_2_3__f_clk/X vssd1 vssd1 vccd1 vccd1 _4605_/CLK sky130_fd_sc_hd__clkbuf_8
X_3849_ _3078_/X _3092_/Y _3091_/X vssd1 vssd1 vccd1 vccd1 _3849_/Y sky130_fd_sc_hd__o21ai_1
XANTENNA_clkbuf_2_1__f_clk_X clkload1/A vssd1 vssd1 vccd1 vccd1 sky130_fd_sc_hd__diode_2
Xfanout120 _2930_/A2 vssd1 vssd1 vccd1 vccd1 _3156_/B1 sky130_fd_sc_hd__buf_1
Xfanout131 _4007_/B2 vssd1 vssd1 vccd1 vccd1 _4122_/B1 sky130_fd_sc_hd__clkbuf_2
Xfanout164 _4246_/X vssd1 vssd1 vccd1 vccd1 _4281_/A1 sky130_fd_sc_hd__clkbuf_2
Xfanout142 _3979_/A2 vssd1 vssd1 vccd1 vccd1 _3983_/B2 sky130_fd_sc_hd__buf_2
Xfanout153 _4334_/A2 vssd1 vssd1 vccd1 vccd1 _4280_/B2 sky130_fd_sc_hd__clkbuf_2
XFILLER_59_332 vssd1 vssd1 vccd1 vccd1 sky130_fd_sc_hd__decap_4
XFILLER_59_354 vssd1 vssd1 vccd1 vccd1 sky130_fd_sc_hd__fill_1
Xfanout175 _3919_/X vssd1 vssd1 vccd1 vccd1 _4372_/B sky130_fd_sc_hd__clkbuf_2
Xfanout186 _3878_/X vssd1 vssd1 vccd1 vccd1 _4020_/A0 sky130_fd_sc_hd__buf_2
Xfanout197 _2346_/X vssd1 vssd1 vccd1 vccd1 _2366_/S sky130_fd_sc_hd__clkbuf_4
XFILLER_47_77 vssd1 vssd1 vccd1 vccd1 sky130_fd_sc_hd__fill_1
XFILLER_27_240 vssd1 vssd1 vccd1 vccd1 sky130_fd_sc_hd__fill_1
XFILLER_42_243 vssd1 vssd1 vccd1 vccd1 sky130_fd_sc_hd__decap_8
XFILLER_63_87 vssd1 vssd1 vccd1 vccd1 sky130_fd_sc_hd__decap_4
XFILLER_42_265 vccd1 vssd1 vccd1 vssd1 sky130_ef_sc_hd__decap_12
Xclkbuf_leaf_22_clk clkbuf_2_3__f_clk/X vssd1 vssd1 vccd1 vccd1 _4647_/CLK sky130_fd_sc_hd__clkbuf_8
XFILLER_10_195 vssd1 vssd1 vccd1 vccd1 sky130_fd_sc_hd__fill_1
XTAP_TAPCELL_ROW_76_875 vssd1 vccd1 sky130_fd_sc_hd__tapvpwrvgnd_1
XANTENNA__4214__A0 _4214_/A0 vssd1 vssd1 vccd1 vccd1 sky130_fd_sc_hd__diode_2
X_4752_ _4782_/CLK _4752_/D fanout396/X vssd1 vssd1 vccd1 vccd1 _4752_/Q sky130_fd_sc_hd__dfrtp_1
Xclkbuf_leaf_13_clk clkload1/A vssd1 vssd1 vccd1 vccd1 _4815_/CLK sky130_fd_sc_hd__clkbuf_8
XTAP_TAPCELL_ROW_31_466 vssd1 vccd1 sky130_fd_sc_hd__tapvpwrvgnd_1
X_4683_ clkload7/A _4683_/D fanout381/X vssd1 vssd1 vccd1 vccd1 _4683_/Q sky130_fd_sc_hd__dfrtp_1
X_3703_ _3701_/X _3702_/Y _3549_/A vssd1 vssd1 vccd1 vccd1 _3703_/Y sky130_fd_sc_hd__o21ai_1
X_3634_ _4594_/Q _3655_/S _3633_/Y _3632_/X vssd1 vssd1 vccd1 vccd1 _4594_/D sky130_fd_sc_hd__a22o_1
X_3565_ _4511_/Q _4620_/Q vssd1 vssd1 vccd1 vccd1 _3567_/D sky130_fd_sc_hd__nand2_1
X_3496_ _3487_/A _3487_/B _3173_/X vssd1 vssd1 vccd1 vccd1 _3496_/Y sky130_fd_sc_hd__a21oi_1
XFILLER_0_309 vccd1 vssd1 vccd1 vssd1 sky130_ef_sc_hd__decap_12
X_2516_ _2516_/A _2516_/B _2516_/C vssd1 vssd1 vccd1 vccd1 _2519_/A sky130_fd_sc_hd__nor3_1
X_2447_ _2445_/Y _2447_/B vssd1 vssd1 vccd1 vccd1 _2448_/B sky130_fd_sc_hd__and2b_1
XFILLER_29_505 vssd1 vssd1 vccd1 vccd1 sky130_fd_sc_hd__fill_1
X_2378_ hold88/X _2377_/X _2382_/S vssd1 vssd1 vccd1 vccd1 _4484_/D sky130_fd_sc_hd__mux2_1
XFILLER_56_313 vccd1 vssd1 vccd1 vssd1 sky130_ef_sc_hd__decap_12
X_4117_ _4116_/B _4173_/A2 _4122_/B1 vssd1 vssd1 vccd1 vccd1 _4117_/Y sky130_fd_sc_hd__o21ai_1
XTAP_TAPCELL_ROW_39_544 vssd1 vccd1 sky130_fd_sc_hd__tapvpwrvgnd_1
X_4048_ _4116_/D _4068_/B _4056_/D _4116_/B vssd1 vssd1 vccd1 vccd1 _4048_/X sky130_fd_sc_hd__and4b_1
XFILLER_71_349 vssd1 vssd1 vccd1 vccd1 sky130_fd_sc_hd__fill_2
XFILLER_24_210 vssd1 vssd1 vccd1 vccd1 sky130_fd_sc_hd__fill_1
XANTENNA__4207__C _4340_/A vssd1 vssd1 vccd1 vccd1 sky130_fd_sc_hd__diode_2
XANTENNA_fanout423_X fanout423/X vssd1 vssd1 vccd1 vccd1 sky130_fd_sc_hd__diode_2
XFILLER_3_125 vccd1 vssd1 vccd1 vssd1 sky130_ef_sc_hd__decap_12
XFILLER_79_449 vccd1 vssd1 vccd1 vssd1 sky130_ef_sc_hd__decap_12
Xhold9 hold9/A vssd1 vssd1 vccd1 vccd1 hold9/X sky130_fd_sc_hd__dlygate4sd3_1
XANTENNA_input29_A s_axis_tdata[4] vssd1 vssd1 vccd1 vccd1 sky130_fd_sc_hd__diode_2
XFILLER_47_335 vssd1 vssd1 vccd1 vccd1 sky130_fd_sc_hd__fill_1
XFILLER_74_143 vccd1 vssd1 vccd1 vssd1 sky130_ef_sc_hd__decap_12
XTAP_TAPCELL_ROW_73_845 vssd1 vccd1 sky130_fd_sc_hd__tapvpwrvgnd_1
XFILLER_74_97 vssd1 vssd1 vccd1 vccd1 sky130_fd_sc_hd__decap_4
XFILLER_30_279 vssd1 vssd1 vccd1 vccd1 sky130_fd_sc_hd__decap_4
XFILLER_7_497 vssd1 vssd1 vccd1 vccd1 sky130_fd_sc_hd__decap_4
X_3350_ _3350_/A _3350_/B vssd1 vssd1 vccd1 vccd1 _3350_/Y sky130_fd_sc_hd__nor2_1
XANTENNA__3959__A1_N _4087_/S vssd1 vssd1 vccd1 vccd1 sky130_fd_sc_hd__diode_2
X_2301_ hold169/X _3999_/B2 _2299_/Y _2300_/X vssd1 vssd1 vccd1 vccd1 _4457_/D sky130_fd_sc_hd__o22a_1
X_3281_ _3282_/A _4589_/Q vssd1 vssd1 vccd1 vccd1 _3286_/C sky130_fd_sc_hd__nor2_1
Xclkbuf_leaf_2_clk clkload0/A vssd1 vssd1 vccd1 vccd1 clkload5/A sky130_fd_sc_hd__clkbuf_8
X_2232_ _4540_/Q input1/X _4539_/Q _4581_/Q vssd1 vssd1 vccd1 vccd1 _2232_/X sky130_fd_sc_hd__and4bb_1
XFILLER_78_493 vssd1 vssd1 vccd1 vccd1 sky130_fd_sc_hd__decap_4
XFILLER_65_121 vssd1 vssd1 vccd1 vccd1 sky130_fd_sc_hd__fill_2
XTAP_TAPCELL_ROW_36_514 vssd1 vccd1 sky130_fd_sc_hd__tapvpwrvgnd_1
XFILLER_61_393 vssd1 vssd1 vccd1 vccd1 sky130_fd_sc_hd__fill_1
XFILLER_61_382 vssd1 vssd1 vccd1 vccd1 sky130_fd_sc_hd__decap_3
X_4804_ _4806_/CLK _4804_/D fanout385/X vssd1 vssd1 vccd1 vccd1 _4804_/Q sky130_fd_sc_hd__dfrtp_2
XANTENNA__4324__A _4324_/A vssd1 vssd1 vccd1 vccd1 sky130_fd_sc_hd__diode_2
X_2996_ _2988_/Y _2989_/X _2996_/C _2996_/D vssd1 vssd1 vccd1 vccd1 _2998_/A sky130_fd_sc_hd__and4bb_1
X_4735_ _4751_/CLK _4735_/D fanout396/X vssd1 vssd1 vccd1 vccd1 _4735_/Q sky130_fd_sc_hd__dfrtp_1
X_4666_ _4667_/CLK _4666_/D fanout412/X vssd1 vssd1 vccd1 vccd1 _4666_/Q sky130_fd_sc_hd__dfrtp_4
XANTENNA_fanout216_A _4377_/C1 vssd1 vssd1 vccd1 vccd1 sky130_fd_sc_hd__diode_2
X_3617_ _4518_/Q _4627_/Q vssd1 vssd1 vccd1 vccd1 _3617_/Y sky130_fd_sc_hd__nor2_1
X_4597_ _4597_/CLK _4597_/D fanout412/X vssd1 vssd1 vccd1 vccd1 _4597_/Q sky130_fd_sc_hd__dfrtp_1
X_3548_ _4509_/Q _4616_/Q _4617_/Q vssd1 vssd1 vccd1 vccd1 _3549_/C sky130_fd_sc_hd__a21o_1
XANTENNA__3713__A2 _3741_/S vssd1 vssd1 vccd1 vccd1 sky130_fd_sc_hd__diode_2
X_3479_ _3474_/B _3474_/A _3475_/A vssd1 vssd1 vccd1 vccd1 _3481_/A sky130_fd_sc_hd__a21o_1
XFILLER_71_113 vssd1 vssd1 vccd1 vccd1 sky130_fd_sc_hd__decap_8
XTAP_TAPCELL_ROW_70_815 vssd1 vccd1 sky130_fd_sc_hd__tapvpwrvgnd_1
XFILLER_12_213 vssd1 vssd1 vccd1 vccd1 sky130_fd_sc_hd__decap_8
XANTENNA__3704__A2 _3549_/A vssd1 vssd1 vccd1 vccd1 sky130_fd_sc_hd__diode_2
XFILLER_4_489 vccd1 vssd1 vccd1 vssd1 sky130_ef_sc_hd__decap_12
XFILLER_79_246 vssd1 vssd1 vccd1 vccd1 sky130_fd_sc_hd__decap_4
XTAP_TAPCELL_ROW_7_250 vssd1 vccd1 sky130_fd_sc_hd__tapvpwrvgnd_1
XANTENNA__4128__B _4136_/B vssd1 vssd1 vccd1 vccd1 sky130_fd_sc_hd__diode_2
XFILLER_47_187 vssd1 vssd1 vccd1 vccd1 sky130_fd_sc_hd__fill_2
XFILLER_35_349 vssd1 vssd1 vccd1 vccd1 sky130_fd_sc_hd__fill_1
XANTENNA__2871__B _4468_/Q vssd1 vssd1 vccd1 vccd1 sky130_fd_sc_hd__diode_2
XANTENNA__2363__S _2365_/S vssd1 vssd1 vccd1 vccd1 sky130_fd_sc_hd__diode_2
XFILLER_43_393 vccd1 vssd1 vccd1 vssd1 sky130_ef_sc_hd__decap_12
X_2850_ _2850_/A _2850_/B _2850_/C vssd1 vssd1 vccd1 vccd1 _2851_/B sky130_fd_sc_hd__nand3_1
XTAP_TAPCELL_ROW_41_561 vssd1 vccd1 sky130_fd_sc_hd__tapvpwrvgnd_1
X_2781_ _2782_/B _2782_/A vssd1 vssd1 vccd1 vccd1 _2783_/A sky130_fd_sc_hd__nor2_1
XANTENNA__4196__A2 _4212_/A2 vssd1 vssd1 vccd1 vccd1 sky130_fd_sc_hd__diode_2
XFILLER_7_250 vssd1 vssd1 vccd1 vccd1 sky130_fd_sc_hd__decap_3
X_4520_ _4702_/CLK _4520_/D fanout410/X vssd1 vssd1 vccd1 vccd1 _4520_/Q sky130_fd_sc_hd__dfrtp_1
Xhold217 _4585_/Q vssd1 vssd1 vccd1 vccd1 hold217/X sky130_fd_sc_hd__dlygate4sd3_1
Xhold206 _4627_/Q vssd1 vssd1 vccd1 vccd1 hold206/X sky130_fd_sc_hd__dlygate4sd3_1
X_4451_ _4579_/CLK _4451_/D _3923_/C vssd1 vssd1 vccd1 vccd1 hold83/A sky130_fd_sc_hd__dfrtp_1
X_3402_ _3398_/A _3398_/B _3228_/Y vssd1 vssd1 vccd1 vccd1 _3406_/C sky130_fd_sc_hd__o21a_1
Xhold228 _4566_/Q vssd1 vssd1 vccd1 vccd1 hold228/X sky130_fd_sc_hd__dlygate4sd3_1
X_4382_ _4123_/S input28/X _4400_/S vssd1 vssd1 vccd1 vccd1 _4791_/D sky130_fd_sc_hd__mux2_1
X_3333_ _4580_/Q _3333_/B _3333_/C _3333_/D vssd1 vssd1 vccd1 vccd1 _3333_/Y sky130_fd_sc_hd__nand4_2
X_3264_ _4542_/Q _4583_/Q _4582_/Q _4541_/Q vssd1 vssd1 vccd1 vccd1 _3264_/Y sky130_fd_sc_hd__a22oi_2
XPHY_EDGE_ROW_7_Right_7 vssd1 vssd1 vccd1 vccd1 sky130_fd_sc_hd__decap_3
X_2215_ hold85/A vssd1 vssd1 vccd1 vccd1 _2880_/B sky130_fd_sc_hd__inv_2
X_3195_ _3195_/A _3195_/B vssd1 vssd1 vccd1 vccd1 _3203_/B sky130_fd_sc_hd__nor2_1
XFILLER_26_327 vssd1 vssd1 vccd1 vccd1 sky130_fd_sc_hd__fill_2
XFILLER_38_165 vssd1 vssd1 vccd1 vccd1 sky130_fd_sc_hd__fill_1
XFILLER_38_176 vccd1 vssd1 vccd1 vssd1 sky130_ef_sc_hd__decap_12
XANTENNA__3877__B _4033_/C vssd1 vssd1 vccd1 vccd1 sky130_fd_sc_hd__diode_2
XFILLER_14_59 vssd1 vssd1 vccd1 vccd1 sky130_fd_sc_hd__fill_2
X_2979_ _2979_/A _2979_/B vssd1 vssd1 vccd1 vccd1 _3000_/A sky130_fd_sc_hd__nand2_1
XANTENNA_fanout219_X _4377_/C1 vssd1 vssd1 vccd1 vccd1 sky130_fd_sc_hd__diode_2
XANTENNA_fanout121_X _2930_/A2 vssd1 vssd1 vccd1 vccd1 sky130_fd_sc_hd__diode_2
X_4718_ _4748_/CLK _4718_/D fanout392/X vssd1 vssd1 vccd1 vccd1 _4718_/Q sky130_fd_sc_hd__dfrtp_1
XFILLER_30_25 vssd1 vssd1 vccd1 vccd1 sky130_fd_sc_hd__fill_1
X_4649_ _4820_/CLK hold38/X _2229_/B vssd1 vssd1 vccd1 vccd1 hold37/A sky130_fd_sc_hd__dfrtp_1
XANTENNA_fanout79_A _3423_/A1 vssd1 vssd1 vccd1 vccd1 sky130_fd_sc_hd__diode_2
XTAP_TAPCELL_ROW_47_609 vssd1 vccd1 sky130_fd_sc_hd__tapvpwrvgnd_1
XFILLER_17_305 vssd1 vssd1 vccd1 vccd1 sky130_fd_sc_hd__decap_4
XTAP_TAPCELL_ROW_83_940 vssd1 vccd1 sky130_fd_sc_hd__tapvpwrvgnd_1
XFILLER_72_455 vssd1 vssd1 vccd1 vccd1 sky130_fd_sc_hd__fill_2
XFILLER_55_55 vssd1 vssd1 vccd1 vccd1 sky130_fd_sc_hd__fill_1
XFILLER_55_66 vssd1 vssd1 vccd1 vccd1 sky130_fd_sc_hd__fill_1
XFILLER_44_168 vssd1 vssd1 vccd1 vccd1 sky130_fd_sc_hd__decap_8
XTAP_TAPCELL_ROW_55_686 vssd1 vccd1 sky130_fd_sc_hd__tapvpwrvgnd_1
XFILLER_40_363 vssd1 vssd1 vccd1 vccd1 sky130_fd_sc_hd__fill_1
XTAP_TAPCELL_ROW_10_277 vssd1 vccd1 sky130_fd_sc_hd__tapvpwrvgnd_1
XANTENNA__2358__S _2366_/S vssd1 vssd1 vccd1 vccd1 sky130_fd_sc_hd__diode_2
XFILLER_75_271 vssd1 vssd1 vccd1 vccd1 sky130_fd_sc_hd__fill_1
XFILLER_35_113 vccd1 vssd1 vccd1 vssd1 sky130_ef_sc_hd__decap_12
XFILLER_48_485 vssd1 vssd1 vccd1 vccd1 sky130_fd_sc_hd__decap_3
XFILLER_75_293 vssd1 vssd1 vccd1 vccd1 sky130_fd_sc_hd__fill_2
XTAP_TAPCELL_ROW_18_355 vssd1 vccd1 sky130_fd_sc_hd__tapvpwrvgnd_1
X_3951_ _4075_/S _3974_/A1 _3950_/Y _3928_/S vssd1 vssd1 vccd1 vccd1 _3951_/X sky130_fd_sc_hd__a211o_1
X_2902_ _2897_/A _2897_/B _2895_/X vssd1 vssd1 vccd1 vccd1 _2916_/A sky130_fd_sc_hd__o21ai_1
X_3882_ _4044_/B _4044_/C _4120_/C vssd1 vssd1 vccd1 vccd1 _3882_/X sky130_fd_sc_hd__and3_1
XANTENNA__4169__A2 _4176_/A2 vssd1 vssd1 vccd1 vccd1 sky130_fd_sc_hd__diode_2
X_2833_ _2869_/B _4701_/Q vssd1 vssd1 vccd1 vccd1 _2833_/X sky130_fd_sc_hd__and2_1
X_2764_ _4744_/Q _4714_/Q vssd1 vssd1 vccd1 vccd1 _2767_/C sky130_fd_sc_hd__nand2_2
X_4503_ _4576_/CLK _4503_/D fanout438/X vssd1 vssd1 vccd1 vccd1 hold12/A sky130_fd_sc_hd__dfrtp_1
X_2695_ _4665_/Q _4757_/Q vssd1 vssd1 vccd1 vccd1 _2753_/A sky130_fd_sc_hd__nand2_1
X_4434_ _4562_/CLK _4434_/D _3923_/C vssd1 vssd1 vccd1 vccd1 hold81/A sky130_fd_sc_hd__dfrtp_1
X_4365_ _4364_/A _4372_/B _4378_/B2 vssd1 vssd1 vccd1 vccd1 _4365_/Y sky130_fd_sc_hd__o21ai_1
XANTENNA__4341__A2 _4328_/C vssd1 vssd1 vccd1 vccd1 sky130_fd_sc_hd__diode_2
X_3316_ _3316_/A _3316_/B vssd1 vssd1 vccd1 vccd1 _3528_/B sky130_fd_sc_hd__nand2_1
XANTENNA__2268__S _2271_/S vssd1 vssd1 vccd1 vccd1 sky130_fd_sc_hd__diode_2
X_4296_ _4295_/Y _4294_/X _4293_/X _4766_/Q _4358_/A2 vssd1 vssd1 vccd1 vccd1 _4766_/D
+ sky130_fd_sc_hd__o32a_1
XANTENNA_clkbuf_leaf_21_clk_A clkbuf_2_3__f_clk/X vssd1 vssd1 vccd1 vccd1 sky130_fd_sc_hd__diode_2
XANTENNA_fanout283_A _4064_/C vssd1 vssd1 vccd1 vccd1 sky130_fd_sc_hd__diode_2
X_3247_ _4552_/Q _4593_/Q _4592_/Q _4551_/Q vssd1 vssd1 vccd1 vccd1 _3247_/X sky130_fd_sc_hd__a22o_1
X_3178_ _4565_/Q _4606_/Q _3301_/A vssd1 vssd1 vccd1 vccd1 _3178_/Y sky130_fd_sc_hd__a21oi_1
XTAP_TAPCELL_ROW_1_201 vssd1 vccd1 sky130_fd_sc_hd__tapvpwrvgnd_1
XTAP_TAPCELL_ROW_80_910 vssd1 vccd1 sky130_fd_sc_hd__tapvpwrvgnd_1
XANTENNA_fanout169_X _4171_/A1 vssd1 vssd1 vccd1 vccd1 sky130_fd_sc_hd__diode_2
XANTENNA_clkbuf_leaf_36_clk_A clkload2/A vssd1 vssd1 vccd1 vccd1 sky130_fd_sc_hd__diode_2
XFILLER_22_352 vccd1 vssd1 vccd1 vssd1 sky130_ef_sc_hd__decap_12
XANTENNA_fanout336_X _4323_/S vssd1 vssd1 vccd1 vccd1 sky130_fd_sc_hd__diode_2
XTAP_TAPCELL_ROW_52_656 vssd1 vccd1 sky130_fd_sc_hd__tapvpwrvgnd_1
XANTENNA__4215__C _4215_/C vssd1 vssd1 vccd1 vccd1 sky130_fd_sc_hd__diode_2
XFILLER_10_503 vssd1 vssd1 vccd1 vccd1 sky130_fd_sc_hd__decap_4
XFILLER_41_24 vssd1 vssd1 vccd1 vccd1 sky130_fd_sc_hd__fill_1
XFILLER_1_234 vssd1 vssd1 vccd1 vccd1 sky130_fd_sc_hd__decap_4
XANTENNA__2343__A1 _4036_/S vssd1 vssd1 vccd1 vccd1 sky130_fd_sc_hd__diode_2
XANTENNA_input11_A s_axis_tdata[17] vssd1 vssd1 vccd1 vccd1 sky130_fd_sc_hd__diode_2
XTAP_TAPCELL_ROW_15_325 vssd1 vccd1 sky130_fd_sc_hd__tapvpwrvgnd_1
XFILLER_40_182 vccd1 vssd1 vccd1 vssd1 sky130_ef_sc_hd__decap_12
XANTENNA__4020__A1 _4020_/A1 vssd1 vssd1 vccd1 vccd1 sky130_fd_sc_hd__diode_2
X_2480_ _4661_/Q _2481_/B vssd1 vssd1 vccd1 vccd1 _2482_/A sky130_fd_sc_hd__and2_1
X_4150_ _4147_/X _4148_/X _4149_/Y _4208_/B1 hold211/X vssd1 vssd1 vccd1 vccd1 _4729_/D
+ sky130_fd_sc_hd__o32a_1
X_3101_ _3101_/A _3101_/B _3145_/A vssd1 vssd1 vccd1 vccd1 _3101_/X sky130_fd_sc_hd__or3b_1
X_4081_ _4215_/C _4081_/A2 _4205_/B2 vssd1 vssd1 vccd1 vccd1 _4081_/Y sky130_fd_sc_hd__o21ai_1
XFILLER_83_517 vssd1 vssd1 vccd1 vccd1 sky130_fd_sc_hd__fill_2
X_3032_ _4766_/Q _4781_/Q _3033_/A vssd1 vssd1 vccd1 vccd1 _3035_/B sky130_fd_sc_hd__a21o_1
XFILLER_36_400 vssd1 vssd1 vccd1 vccd1 sky130_fd_sc_hd__fill_2
XFILLER_48_293 vssd1 vssd1 vccd1 vccd1 sky130_fd_sc_hd__fill_2
XFILLER_36_466 vssd1 vssd1 vccd1 vccd1 sky130_fd_sc_hd__fill_2
XANTENNA__4316__B _4328_/B vssd1 vssd1 vccd1 vccd1 sky130_fd_sc_hd__diode_2
XFILLER_51_447 vssd1 vssd1 vccd1 vccd1 sky130_fd_sc_hd__fill_1
X_3934_ _2274_/B _3943_/A2 _3932_/X _3933_/X vssd1 vssd1 vccd1 vccd1 _4671_/D sky130_fd_sc_hd__a31o_1
X_3865_ _3865_/A _3865_/B vssd1 vssd1 vccd1 vccd1 _3866_/B sky130_fd_sc_hd__xor2_1
X_2816_ _2816_/A _2816_/B vssd1 vssd1 vccd1 vccd1 _2816_/X sky130_fd_sc_hd__xor2_1
XANTENNA__4332__A _4332_/A vssd1 vssd1 vccd1 vccd1 sky130_fd_sc_hd__diode_2
X_3796_ _4658_/Q _4670_/Q vssd1 vssd1 vccd1 vccd1 _3796_/Y sky130_fd_sc_hd__nor2_1
XANTENNA_fanout129_A _2274_/Y vssd1 vssd1 vccd1 vccd1 sky130_fd_sc_hd__diode_2
X_2747_ _2748_/B _2748_/A vssd1 vssd1 vccd1 vccd1 _2747_/Y sky130_fd_sc_hd__nor2_1
X_2678_ _2679_/A _4755_/Q _4664_/Q vssd1 vssd1 vccd1 vccd1 _2678_/X sky130_fd_sc_hd__and3_1
X_4417_ _4546_/CLK _4417_/D fanout417/X vssd1 vssd1 vccd1 vccd1 hold29/A sky130_fd_sc_hd__dfrtp_1
Xfanout302 _4801_/Q vssd1 vssd1 vccd1 vccd1 _4368_/A sky130_fd_sc_hd__buf_2
Xfanout313 _4797_/Q vssd1 vssd1 vccd1 vccd1 _4219_/C sky130_fd_sc_hd__buf_2
X_4348_ _4348_/A _4371_/B _4371_/C vssd1 vssd1 vccd1 vccd1 _4348_/X sky130_fd_sc_hd__and3_1
Xfanout335 _4328_/A vssd1 vssd1 vccd1 vccd1 _3935_/S sky130_fd_sc_hd__buf_1
Xfanout346 _4316_/A vssd1 vssd1 vccd1 vccd1 _3981_/D sky130_fd_sc_hd__buf_2
XANTENNA_input3_A s_axis_tdata[0] vssd1 vssd1 vccd1 vccd1 sky130_fd_sc_hd__diode_2
Xfanout324 _4794_/Q vssd1 vssd1 vccd1 vccd1 _4274_/D sky130_fd_sc_hd__buf_2
Xfanout357 _4648_/Q vssd1 vssd1 vccd1 vccd1 _3543_/B sky130_fd_sc_hd__clkbuf_2
X_4279_ _4344_/A _4279_/A2 _4280_/B2 vssd1 vssd1 vccd1 vccd1 _4279_/Y sky130_fd_sc_hd__o21ai_1
Xfanout379 fanout405/X vssd1 vssd1 vccd1 vccd1 fanout379/X sky130_fd_sc_hd__clkbuf_2
XANTENNA_fanout286_X _4100_/C vssd1 vssd1 vccd1 vccd1 sky130_fd_sc_hd__diode_2
Xfanout368 _4614_/Q vssd1 vssd1 vccd1 vccd1 fanout368/X sky130_fd_sc_hd__buf_1
XFILLER_86_377 vssd1 vssd1 vccd1 vccd1 sky130_fd_sc_hd__decap_3
XFILLER_27_411 vssd1 vssd1 vccd1 vccd1 sky130_fd_sc_hd__fill_1
XTAP_TAPCELL_ROW_57_704 vssd1 vccd1 sky130_fd_sc_hd__tapvpwrvgnd_1
XPHY_EDGE_ROW_61_Left_149 vssd1 vssd1 vccd1 vccd1 sky130_fd_sc_hd__decap_3
XTAP_TAPCELL_ROW_65_770 vssd1 vccd1 sky130_fd_sc_hd__tapvpwrvgnd_1
XFILLER_10_333 vssd1 vssd1 vccd1 vccd1 sky130_fd_sc_hd__decap_8
XANTENNA__4002__A1 _4063_/S vssd1 vssd1 vccd1 vccd1 sky130_fd_sc_hd__diode_2
XPHY_EDGE_ROW_70_Left_158 vssd1 vssd1 vccd1 vccd1 sky130_fd_sc_hd__decap_3
XFILLER_10_388 vssd1 vssd1 vccd1 vccd1 sky130_fd_sc_hd__decap_3
XTAP_TAPCELL_ROW_20_372 vssd1 vccd1 sky130_fd_sc_hd__tapvpwrvgnd_1
XANTENNA__4388__S _4408_/S vssd1 vssd1 vccd1 vccd1 sky130_fd_sc_hd__diode_2
XANTENNA__2316__A1 _4075_/S vssd1 vssd1 vccd1 vccd1 sky130_fd_sc_hd__diode_2
XFILLER_77_53 vssd1 vssd1 vccd1 vccd1 sky130_fd_sc_hd__decap_3
XANTENNA__4069__A1 _4203_/C vssd1 vssd1 vccd1 vccd1 sky130_fd_sc_hd__diode_2
XANTENNA__4136__B _4136_/B vssd1 vssd1 vccd1 vccd1 sky130_fd_sc_hd__diode_2
XFILLER_33_447 vssd1 vssd1 vccd1 vccd1 sky130_fd_sc_hd__fill_1
XFILLER_60_266 vssd1 vssd1 vccd1 vccd1 sky130_fd_sc_hd__fill_1
X_3650_ _3648_/A _3647_/B _3647_/A vssd1 vssd1 vccd1 vccd1 _3654_/A sky130_fd_sc_hd__o21ba_1
X_3581_ _4512_/Q _4621_/Q _3580_/Y vssd1 vssd1 vccd1 vccd1 _3581_/X sky130_fd_sc_hd__o21a_1
X_2601_ _2601_/A _2601_/B vssd1 vssd1 vccd1 vccd1 _2612_/A sky130_fd_sc_hd__and2_1
X_2532_ _2554_/A _2532_/B vssd1 vssd1 vccd1 vccd1 _2532_/X sky130_fd_sc_hd__or2_1
XFILLER_54_3 vssd1 vssd1 vccd1 vccd1 sky130_fd_sc_hd__decap_4
X_2463_ _4688_/Q _4675_/Q vssd1 vssd1 vccd1 vccd1 _2464_/B sky130_fd_sc_hd__xor2_1
X_4202_ _4214_/A0 _4210_/A1 _4340_/A vssd1 vssd1 vccd1 vccd1 _4202_/X sky130_fd_sc_hd__mux2_1
X_2394_ hold70/X _2393_/X _2426_/S vssd1 vssd1 vccd1 vccd1 _4492_/D sky130_fd_sc_hd__mux2_1
X_4133_ _4266_/D _4173_/A2 _4193_/B2 vssd1 vssd1 vccd1 vccd1 _4133_/Y sky130_fd_sc_hd__o21ai_1
X_4064_ _4132_/C _4068_/B _4064_/C _4064_/D vssd1 vssd1 vccd1 vccd1 _4064_/X sky130_fd_sc_hd__and4b_1
X_3015_ hold178/X _3157_/A2 _3001_/A _3014_/Y vssd1 vssd1 vccd1 vccd1 _4532_/D sky130_fd_sc_hd__o22a_1
XFILLER_24_425 vssd1 vssd1 vccd1 vccd1 sky130_fd_sc_hd__fill_1
XTAP_TAPCELL_ROW_62_751 vssd1 vccd1 sky130_fd_sc_hd__tapvpwrvgnd_1
XFILLER_51_255 vssd1 vssd1 vccd1 vccd1 sky130_fd_sc_hd__decap_3
XANTENNA__4232__A1 _4364_/A vssd1 vssd1 vccd1 vccd1 sky130_fd_sc_hd__diode_2
XANTENNA_fanout246_A _2419_/S vssd1 vssd1 vccd1 vccd1 sky130_fd_sc_hd__diode_2
XTAP_TAPCELL_ROW_34_497 vssd1 vccd1 sky130_fd_sc_hd__tapvpwrvgnd_1
X_3917_ _4377_/C1 _4377_/B1 hold195/X vssd1 vssd1 vccd1 vccd1 _3917_/Y sky130_fd_sc_hd__a21oi_1
X_3848_ hold175/X _3848_/A2 _3847_/Y vssd1 vssd1 vccd1 vccd1 _4642_/D sky130_fd_sc_hd__a21o_1
XANTENNA_fanout413_A fanout414/X vssd1 vssd1 vccd1 vccd1 sky130_fd_sc_hd__diode_2
X_3779_ _4537_/Q _4646_/Q vssd1 vssd1 vccd1 vccd1 _3780_/A sky130_fd_sc_hd__xor2_2
XANTENNA_fanout201_X _2424_/S vssd1 vssd1 vccd1 vccd1 sky130_fd_sc_hd__diode_2
XANTENNA__4299__A1 _4364_/A vssd1 vssd1 vccd1 vccd1 sky130_fd_sc_hd__diode_2
Xfanout110 _3828_/A2 vssd1 vssd1 vccd1 vccd1 _3830_/A2 sky130_fd_sc_hd__buf_2
Xfanout121 _2427_/X vssd1 vssd1 vccd1 vccd1 _2930_/A2 sky130_fd_sc_hd__clkbuf_2
Xfanout165 _4246_/X vssd1 vssd1 vccd1 vccd1 _4305_/A1 sky130_fd_sc_hd__clkbuf_2
Xfanout143 _3922_/B1 vssd1 vssd1 vccd1 vccd1 _3979_/A2 sky130_fd_sc_hd__dlymetal6s2s_1
Xfanout132 _2321_/B2 vssd1 vssd1 vccd1 vccd1 _4007_/B2 sky130_fd_sc_hd__clkbuf_2
Xfanout154 _4338_/A2 vssd1 vssd1 vccd1 vccd1 _4334_/A2 sky130_fd_sc_hd__clkbuf_2
XFILLER_74_303 vssd1 vssd1 vccd1 vccd1 sky130_fd_sc_hd__decap_4
Xfanout176 _3897_/Y vssd1 vssd1 vccd1 vccd1 _4339_/A0 sky130_fd_sc_hd__clkbuf_2
Xfanout187 _3878_/X vssd1 vssd1 vccd1 vccd1 _4036_/A0 sky130_fd_sc_hd__clkbuf_2
Xfanout198 _2346_/X vssd1 vssd1 vccd1 vccd1 _2382_/S sky130_fd_sc_hd__buf_2
XFILLER_74_347 vssd1 vssd1 vccd1 vccd1 sky130_fd_sc_hd__decap_3
XFILLER_27_230 vssd1 vssd1 vccd1 vccd1 sky130_fd_sc_hd__fill_1
XFILLER_63_22 vssd1 vssd1 vccd1 vccd1 sky130_fd_sc_hd__fill_1
XFILLER_63_55 vssd1 vssd1 vccd1 vccd1 sky130_fd_sc_hd__fill_1
XFILLER_63_99 vssd1 vssd1 vccd1 vccd1 sky130_fd_sc_hd__decap_3
XFILLER_42_277 vssd1 vssd1 vccd1 vccd1 sky130_fd_sc_hd__decap_8
XFILLER_10_141 vccd1 vssd1 vccd1 vssd1 sky130_ef_sc_hd__decap_12
XFILLER_65_347 vssd1 vssd1 vccd1 vccd1 sky130_fd_sc_hd__decap_6
XTAP_TAPCELL_ROW_76_876 vssd1 vccd1 sky130_fd_sc_hd__tapvpwrvgnd_1
XANTENNA__2366__S _2366_/S vssd1 vssd1 vccd1 vccd1 sky130_fd_sc_hd__diode_2
XFILLER_18_230 vssd1 vssd1 vccd1 vccd1 sky130_fd_sc_hd__fill_2
X_4820_ _4820_/CLK _4820_/D fanout422/X vssd1 vssd1 vccd1 vccd1 hold67/A sky130_fd_sc_hd__dfrtp_1
X_4751_ _4751_/CLK _4751_/D fanout396/X vssd1 vssd1 vccd1 vccd1 _4751_/Q sky130_fd_sc_hd__dfrtp_1
X_4682_ clkload7/A _4682_/D fanout381/X vssd1 vssd1 vccd1 vccd1 _4682_/Q sky130_fd_sc_hd__dfrtp_1
XTAP_TAPCELL_ROW_31_467 vssd1 vccd1 sky130_fd_sc_hd__tapvpwrvgnd_1
X_3702_ _3701_/A _3709_/A _3725_/B vssd1 vssd1 vccd1 vccd1 _3702_/Y sky130_fd_sc_hd__a21oi_1
X_3633_ _3643_/C _3632_/B _3655_/S vssd1 vssd1 vccd1 vccd1 _3633_/Y sky130_fd_sc_hd__a21oi_1
X_3564_ _4511_/Q _4620_/Q vssd1 vssd1 vccd1 vccd1 _3564_/X sky130_fd_sc_hd__and2_1
X_3495_ _4570_/Q _3522_/A2 _3493_/X _3494_/X vssd1 vssd1 vccd1 vccd1 _4570_/D sky130_fd_sc_hd__a22o_1
X_2515_ _4691_/Q _4678_/Q vssd1 vssd1 vccd1 vccd1 _2516_/A sky130_fd_sc_hd__nor2_1
X_2446_ _2445_/A _2445_/B _4454_/Q vssd1 vssd1 vccd1 vccd1 _2447_/B sky130_fd_sc_hd__o21bai_1
XFILLER_68_141 vssd1 vssd1 vccd1 vccd1 sky130_fd_sc_hd__fill_1
X_4116_ _4199_/D _4116_/B _4136_/B _4116_/D vssd1 vssd1 vccd1 vccd1 _4116_/X sky130_fd_sc_hd__and4b_1
X_2377_ _4556_/Q hold28/A _2381_/S vssd1 vssd1 vccd1 vccd1 _2377_/X sky130_fd_sc_hd__mux2_1
XFILLER_56_325 vssd1 vssd1 vccd1 vccd1 sky130_fd_sc_hd__fill_2
X_4047_ _4099_/A0 _4083_/A1 _4120_/D vssd1 vssd1 vccd1 vccd1 _4047_/X sky130_fd_sc_hd__mux2_1
XANTENNA_fanout363_A _3541_/B1 vssd1 vssd1 vccd1 vccd1 sky130_fd_sc_hd__diode_2
XFILLER_64_380 vssd1 vssd1 vccd1 vccd1 sky130_fd_sc_hd__decap_6
XFILLER_24_222 vssd1 vssd1 vccd1 vccd1 sky130_fd_sc_hd__decap_6
XANTENNA__4207__D _4239_/D vssd1 vssd1 vccd1 vccd1 sky130_fd_sc_hd__diode_2
XFILLER_12_406 vccd1 vssd1 vccd1 vssd1 sky130_ef_sc_hd__decap_12
XFILLER_24_277 vccd1 vssd1 vccd1 vssd1 sky130_ef_sc_hd__decap_12
XANTENNA__4223__C _4223_/C vssd1 vssd1 vccd1 vccd1 sky130_fd_sc_hd__diode_2
XFILLER_3_137 vccd1 vssd1 vccd1 vssd1 sky130_ef_sc_hd__decap_12
XANTENNA__4566__RESET_B fanout435/X vssd1 vssd1 vccd1 vccd1 sky130_fd_sc_hd__diode_2
XFILLER_58_44 vssd1 vssd1 vccd1 vccd1 sky130_fd_sc_hd__decap_8
XFILLER_87_472 vssd1 vssd1 vccd1 vccd1 sky130_fd_sc_hd__decap_4
XFILLER_87_461 vssd1 vssd1 vccd1 vccd1 sky130_fd_sc_hd__decap_3
XANTENNA__3495__A2 _3522_/A2 vssd1 vssd1 vccd1 vccd1 sky130_fd_sc_hd__diode_2
XFILLER_59_163 vssd1 vssd1 vccd1 vccd1 sky130_fd_sc_hd__decap_4
XFILLER_87_483 vccd1 vssd1 vccd1 vssd1 sky130_ef_sc_hd__decap_12
XFILLER_74_155 vssd1 vssd1 vccd1 vccd1 sky130_fd_sc_hd__decap_3
XFILLER_74_133 vssd1 vssd1 vccd1 vccd1 sky130_fd_sc_hd__fill_1
XFILLER_62_306 vssd1 vssd1 vccd1 vccd1 sky130_fd_sc_hd__fill_2
XFILLER_74_188 vssd1 vssd1 vccd1 vccd1 sky130_fd_sc_hd__fill_2
XTAP_TAPCELL_ROW_73_846 vssd1 vccd1 sky130_fd_sc_hd__tapvpwrvgnd_1
XFILLER_55_391 vssd1 vssd1 vccd1 vccd1 sky130_fd_sc_hd__fill_1
XANTENNA__4380__A0 _4120_/D vssd1 vssd1 vccd1 vccd1 sky130_fd_sc_hd__diode_2
X_2300_ _4064_/D _2295_/C _2295_/B _3886_/S _2298_/X vssd1 vssd1 vccd1 vccd1 _2300_/X
+ sky130_fd_sc_hd__a311o_1
X_3280_ _3393_/A _3284_/B _3380_/C vssd1 vssd1 vccd1 vccd1 _3280_/X sky130_fd_sc_hd__and3_1
X_2231_ input1/X _4539_/Q vssd1 vssd1 vccd1 vccd1 _3158_/A sky130_fd_sc_hd__nand2b_1
XFILLER_65_111 vssd1 vssd1 vccd1 vccd1 sky130_fd_sc_hd__fill_1
XFILLER_65_133 vssd1 vssd1 vccd1 vccd1 sky130_fd_sc_hd__decap_3
XFILLER_80_103 vssd1 vssd1 vccd1 vccd1 sky130_fd_sc_hd__decap_3
XTAP_TAPCELL_ROW_36_515 vssd1 vccd1 sky130_fd_sc_hd__tapvpwrvgnd_1
X_4803_ _4817_/CLK _4803_/D fanout395/X vssd1 vssd1 vccd1 vccd1 _4803_/Q sky130_fd_sc_hd__dfrtp_4
XTAP_TAPCELL_ROW_44_581 vssd1 vccd1 sky130_fd_sc_hd__tapvpwrvgnd_1
X_2995_ _2996_/C _2996_/D vssd1 vssd1 vccd1 vccd1 _2995_/Y sky130_fd_sc_hd__nand2_1
X_4734_ _4751_/CLK _4734_/D fanout394/X vssd1 vssd1 vccd1 vccd1 _4734_/Q sky130_fd_sc_hd__dfrtp_1
X_4665_ _4774_/CLK _4665_/D fanout399/X vssd1 vssd1 vccd1 vccd1 _4665_/Q sky130_fd_sc_hd__dfrtp_1
XANTENNA_fanout209_A _2274_/A vssd1 vssd1 vccd1 vccd1 sky130_fd_sc_hd__diode_2
X_3616_ _4518_/Q _4627_/Q vssd1 vssd1 vccd1 vccd1 _3616_/X sky130_fd_sc_hd__and2_1
X_4596_ _4597_/CLK _4596_/D fanout412/X vssd1 vssd1 vccd1 vccd1 _4596_/Q sky130_fd_sc_hd__dfrtp_1
XANTENNA_fanout111_A _2428_/Y vssd1 vssd1 vccd1 vccd1 sky130_fd_sc_hd__diode_2
XANTENNA__4340__A _4340_/A vssd1 vssd1 vccd1 vccd1 sky130_fd_sc_hd__diode_2
X_3547_ _4509_/Q _4616_/Q _4617_/Q vssd1 vssd1 vccd1 vccd1 _3558_/A sky130_fd_sc_hd__nand3_1
X_3478_ _4567_/Q _3522_/A2 _3476_/X _3477_/X vssd1 vssd1 vccd1 vccd1 _4567_/D sky130_fd_sc_hd__a22o_1
XANTENNA__4123__A0 _4167_/A0 vssd1 vssd1 vccd1 vccd1 sky130_fd_sc_hd__diode_2
X_2429_ hold86/X _4509_/Q _3795_/S vssd1 vssd1 vccd1 vccd1 _4509_/D sky130_fd_sc_hd__mux2_1
XFILLER_37_391 vssd1 vssd1 vccd1 vccd1 sky130_fd_sc_hd__fill_1
XTAP_TAPCELL_ROW_70_816 vssd1 vccd1 sky130_fd_sc_hd__tapvpwrvgnd_1
XFILLER_12_269 vssd1 vssd1 vccd1 vccd1 sky130_fd_sc_hd__fill_1
XANTENNA__3401__A2 _3425_/A2 vssd1 vssd1 vccd1 vccd1 sky130_fd_sc_hd__diode_2
XFILLER_79_258 vssd1 vssd1 vccd1 vccd1 sky130_fd_sc_hd__fill_1
XPHY_EDGE_ROW_8_Left_96 vssd1 vssd1 vccd1 vccd1 sky130_fd_sc_hd__decap_3
XTAP_TAPCELL_ROW_7_251 vssd1 vccd1 sky130_fd_sc_hd__tapvpwrvgnd_1
XANTENNA__4396__S _4397_/S vssd1 vssd1 vccd1 vccd1 sky130_fd_sc_hd__diode_2
XFILLER_47_100 vccd1 vssd1 vccd1 vssd1 sky130_ef_sc_hd__decap_12
XFILLER_85_86 vccd1 vssd1 vccd1 vssd1 sky130_ef_sc_hd__decap_12
XTAP_TAPCELL_ROW_86_960 vssd1 vccd1 sky130_fd_sc_hd__tapvpwrvgnd_1
XFILLER_50_309 vccd1 vssd1 vccd1 vssd1 sky130_ef_sc_hd__decap_12
XANTENNA__3640__A2 _3549_/A vssd1 vssd1 vccd1 vccd1 sky130_fd_sc_hd__diode_2
XFILLER_70_191 vssd1 vssd1 vccd1 vccd1 sky130_fd_sc_hd__decap_4
XTAP_TAPCELL_ROW_41_562 vssd1 vccd1 sky130_fd_sc_hd__tapvpwrvgnd_1
X_2780_ _2780_/A _2780_/B vssd1 vssd1 vccd1 vccd1 _2782_/B sky130_fd_sc_hd__nor2_1
Xhold207 _4639_/Q vssd1 vssd1 vccd1 vccd1 hold207/X sky130_fd_sc_hd__dlygate4sd3_1
X_4450_ _4579_/CLK _4450_/D fanout433/X vssd1 vssd1 vccd1 vccd1 hold75/A sky130_fd_sc_hd__dfrtp_1
Xhold218 _4538_/Q vssd1 vssd1 vccd1 vccd1 hold218/X sky130_fd_sc_hd__dlygate4sd3_1
X_4381_ _4119_/S input25/X _4400_/S vssd1 vssd1 vccd1 vccd1 _4790_/D sky130_fd_sc_hd__mux2_1
X_3401_ _4553_/Q _3425_/A2 _3399_/X _3400_/X vssd1 vssd1 vccd1 vccd1 _4553_/D sky130_fd_sc_hd__a22o_1
X_3332_ _3333_/D _4580_/Q _3333_/B _3535_/A _3503_/A2 vssd1 vssd1 vccd1 vccd1 _3332_/Y
+ sky130_fd_sc_hd__o41ai_4
X_3263_ _4542_/Q _4583_/Q vssd1 vssd1 vccd1 vccd1 _3338_/B sky130_fd_sc_hd__and2_1
XFILLER_58_409 vssd1 vssd1 vccd1 vccd1 sky130_fd_sc_hd__decap_8
X_2214_ hold92/A vssd1 vssd1 vccd1 vccd1 _2911_/B sky130_fd_sc_hd__inv_2
X_3194_ _4563_/Q _4604_/Q vssd1 vssd1 vccd1 vccd1 _3195_/B sky130_fd_sc_hd__nor2_1
XFILLER_66_475 vssd1 vssd1 vccd1 vccd1 sky130_fd_sc_hd__fill_1
XFILLER_19_391 vssd1 vssd1 vccd1 vccd1 sky130_fd_sc_hd__fill_1
XFILLER_53_169 vssd1 vssd1 vccd1 vccd1 sky130_fd_sc_hd__decap_3
XFILLER_14_16 vssd1 vssd1 vccd1 vccd1 sky130_fd_sc_hd__fill_1
X_2978_ _2978_/A _2978_/B vssd1 vssd1 vccd1 vccd1 _2979_/B sky130_fd_sc_hd__nor2_1
XANTENNA_fanout326_A _4794_/Q vssd1 vssd1 vccd1 vccd1 sky130_fd_sc_hd__diode_2
X_4717_ _4748_/CLK _4717_/D fanout389/X vssd1 vssd1 vccd1 vccd1 _4717_/Q sky130_fd_sc_hd__dfrtp_1
XFILLER_30_37 vssd1 vssd1 vccd1 vccd1 sky130_fd_sc_hd__fill_1
X_4648_ _4667_/CLK _4648_/D fanout412/X vssd1 vssd1 vccd1 vccd1 _4648_/Q sky130_fd_sc_hd__dfrtp_1
X_4579_ _4579_/CLK _4579_/D fanout433/X vssd1 vssd1 vccd1 vccd1 _4579_/Q sky130_fd_sc_hd__dfrtp_1
XTAP_TAPCELL_ROW_4_221 vssd1 vccd1 sky130_fd_sc_hd__tapvpwrvgnd_1
XFILLER_84_272 vssd1 vssd1 vccd1 vccd1 sky130_fd_sc_hd__fill_2
XFILLER_29_166 vssd1 vssd1 vccd1 vccd1 sky130_fd_sc_hd__fill_2
XANTENNA__3870__A2 _3613_/B vssd1 vssd1 vccd1 vccd1 sky130_fd_sc_hd__diode_2
XFILLER_32_309 vssd1 vssd1 vccd1 vccd1 sky130_fd_sc_hd__decap_8
XTAP_TAPCELL_ROW_55_687 vssd1 vccd1 sky130_fd_sc_hd__tapvpwrvgnd_1
XFILLER_71_55 vssd1 vssd1 vccd1 vccd1 sky130_fd_sc_hd__fill_1
XFILLER_40_331 vssd1 vssd1 vccd1 vccd1 sky130_fd_sc_hd__decap_4
XTAP_TAPCELL_ROW_10_278 vssd1 vccd1 sky130_fd_sc_hd__tapvpwrvgnd_1
XFILLER_67_239 vssd1 vssd1 vccd1 vccd1 sky130_fd_sc_hd__fill_2
Xhold90 hold90/A vssd1 vssd1 vccd1 vccd1 hold90/X sky130_fd_sc_hd__dlygate4sd3_1
XFILLER_35_125 vssd1 vssd1 vccd1 vccd1 sky130_fd_sc_hd__decap_8
X_3950_ _3873_/Y _3950_/A2 _4071_/S _3899_/Y vssd1 vssd1 vccd1 vccd1 _3950_/Y sky130_fd_sc_hd__o22ai_1
X_2901_ _2899_/A _2900_/X _4528_/Q _2985_/A2 vssd1 vssd1 vccd1 vccd1 _4528_/D sky130_fd_sc_hd__o2bb2a_1
X_3881_ _4068_/B _4056_/D vssd1 vssd1 vccd1 vccd1 _4044_/C sky130_fd_sc_hd__nand2_1
XFILLER_84_3 vccd1 vssd1 vccd1 vssd1 sky130_ef_sc_hd__decap_12
XFILLER_31_386 vssd1 vssd1 vccd1 vccd1 sky130_fd_sc_hd__fill_1
X_2832_ _4526_/Q _2985_/A2 _2815_/X _2831_/Y vssd1 vssd1 vccd1 vccd1 _4526_/D sky130_fd_sc_hd__o22a_1
XFILLER_31_397 vccd1 vssd1 vccd1 vssd1 sky130_ef_sc_hd__decap_12
X_2763_ _2758_/A _2758_/C _2758_/B vssd1 vssd1 vccd1 vccd1 _2782_/A sky130_fd_sc_hd__a21boi_1
X_4502_ _4577_/CLK _4502_/D fanout437/X vssd1 vssd1 vccd1 vccd1 hold84/A sky130_fd_sc_hd__dfrtp_1
X_2694_ _4665_/Q _4757_/Q vssd1 vssd1 vccd1 vccd1 _2694_/X sky130_fd_sc_hd__and2_1
XFILLER_6_83 vssd1 vssd1 vccd1 vccd1 sky130_fd_sc_hd__fill_1
X_4433_ _4579_/CLK _4433_/D fanout432/X vssd1 vssd1 vccd1 vccd1 hold54/A sky130_fd_sc_hd__dfrtp_1
X_4364_ _4364_/A _4371_/B _4371_/C vssd1 vssd1 vccd1 vccd1 _4364_/X sky130_fd_sc_hd__and3_1
XANTENNA__4341__A3 _4328_/B vssd1 vssd1 vccd1 vccd1 sky130_fd_sc_hd__diode_2
X_3315_ _4573_/Q _4574_/Q _4575_/Q _4576_/Q _3311_/B vssd1 vssd1 vccd1 vccd1 _3316_/B
+ sky130_fd_sc_hd__o41ai_1
X_4295_ _4360_/A _4307_/A2 _4295_/B1 vssd1 vssd1 vccd1 vccd1 _4295_/Y sky130_fd_sc_hd__o21ai_1
X_3246_ _3279_/B _3380_/A _3243_/Y vssd1 vssd1 vccd1 vccd1 _3246_/Y sky130_fd_sc_hd__a21oi_1
XFILLER_66_261 vssd1 vssd1 vccd1 vccd1 sky130_fd_sc_hd__fill_1
X_3177_ _4566_/Q _4607_/Q vssd1 vssd1 vccd1 vccd1 _3301_/C sky130_fd_sc_hd__nor2_1
XTAP_TAPCELL_ROW_1_202 vssd1 vccd1 sky130_fd_sc_hd__tapvpwrvgnd_1
XTAP_TAPCELL_ROW_80_911 vssd1 vccd1 sky130_fd_sc_hd__tapvpwrvgnd_1
XFILLER_14_309 vssd1 vssd1 vccd1 vccd1 sky130_fd_sc_hd__decap_6
XFILLER_34_191 vssd1 vssd1 vccd1 vccd1 sky130_fd_sc_hd__fill_1
XTAP_TAPCELL_ROW_52_657 vssd1 vccd1 sky130_fd_sc_hd__tapvpwrvgnd_1
XFILLER_22_386 vssd1 vssd1 vccd1 vccd1 sky130_fd_sc_hd__fill_2
XANTENNA__4004__S _4071_/S vssd1 vssd1 vccd1 vccd1 sky130_fd_sc_hd__diode_2
XFILLER_41_69 vccd1 vssd1 vccd1 vssd1 sky130_ef_sc_hd__decap_12
XANTENNA__4231__C _4231_/C vssd1 vssd1 vccd1 vccd1 sky130_fd_sc_hd__diode_2
XANTENNA_fanout91_A _4411_/S vssd1 vssd1 vccd1 vccd1 sky130_fd_sc_hd__diode_2
XFILLER_64_209 vssd1 vssd1 vccd1 vccd1 sky130_fd_sc_hd__decap_4
XFILLER_57_250 vccd1 vssd1 vccd1 vssd1 sky130_ef_sc_hd__decap_12
XFILLER_57_272 vssd1 vssd1 vccd1 vccd1 sky130_fd_sc_hd__decap_8
XFILLER_72_253 vssd1 vssd1 vccd1 vccd1 sky130_fd_sc_hd__fill_2
XFILLER_17_169 vssd1 vssd1 vccd1 vccd1 sky130_fd_sc_hd__decap_6
XFILLER_82_54 vssd1 vssd1 vccd1 vccd1 sky130_fd_sc_hd__decap_8
XTAP_TAPCELL_ROW_15_326 vssd1 vccd1 sky130_fd_sc_hd__tapvpwrvgnd_1
XFILLER_13_353 vssd1 vssd1 vccd1 vccd1 sky130_fd_sc_hd__fill_1
XFILLER_9_335 vssd1 vssd1 vccd1 vccd1 sky130_fd_sc_hd__fill_1
XTAP_TAPCELL_ROW_23_392 vssd1 vccd1 sky130_fd_sc_hd__tapvpwrvgnd_1
XFILLER_40_194 vssd1 vssd1 vccd1 vccd1 sky130_fd_sc_hd__fill_2
XANTENNA__2369__S _2369_/S vssd1 vssd1 vccd1 vccd1 sky130_fd_sc_hd__diode_2
XANTENNA__3538__B1_N _3504_/A2 vssd1 vssd1 vccd1 vccd1 sky130_fd_sc_hd__diode_2
X_3100_ _3101_/A _3101_/B vssd1 vssd1 vccd1 vccd1 _3100_/Y sky130_fd_sc_hd__nor2_1
X_4080_ _4148_/C _4104_/B _4104_/C _4215_/C vssd1 vssd1 vccd1 vccd1 _4080_/X sky130_fd_sc_hd__and4b_1
X_3031_ _3025_/A _2993_/A _2991_/Y vssd1 vssd1 vccd1 vccd1 _3031_/X sky130_fd_sc_hd__o21a_1
XFILLER_55_209 vccd1 vssd1 vccd1 vssd1 sky130_ef_sc_hd__decap_12
XFILLER_36_434 vssd1 vssd1 vccd1 vccd1 sky130_fd_sc_hd__fill_1
XANTENNA__4316__C _4328_/C vssd1 vssd1 vccd1 vccd1 sky130_fd_sc_hd__diode_2
XANTENNA__3928__S _3928_/S vssd1 vssd1 vccd1 vccd1 sky130_fd_sc_hd__diode_2
X_3933_ _3985_/D _3900_/X _3900_/B _4671_/Q vssd1 vssd1 vccd1 vccd1 _3933_/X sky130_fd_sc_hd__a2bb2o_1
X_3864_ _3864_/A _3864_/B vssd1 vssd1 vccd1 vccd1 _3865_/B sky130_fd_sc_hd__nand2_1
X_2815_ _2816_/B _2816_/A vssd1 vssd1 vccd1 vccd1 _2815_/X sky130_fd_sc_hd__and2b_1
X_3795_ hold96/X _4616_/Q _3795_/S vssd1 vssd1 vccd1 vccd1 _4616_/D sky130_fd_sc_hd__mux2_1
X_2746_ _2746_/A _2746_/B vssd1 vssd1 vccd1 vccd1 _2748_/A sky130_fd_sc_hd__xnor2_1
X_2677_ _2629_/B _2629_/A _2629_/C vssd1 vssd1 vccd1 vccd1 _2679_/A sky130_fd_sc_hd__o21bai_1
X_4416_ _4546_/CLK _4416_/D fanout417/X vssd1 vssd1 vccd1 vccd1 hold25/A sky130_fd_sc_hd__dfrtp_1
Xfanout314 _4797_/Q vssd1 vssd1 vccd1 vccd1 _4352_/A sky130_fd_sc_hd__clkbuf_2
Xfanout303 _4801_/Q vssd1 vssd1 vccd1 vccd1 _4033_/D sky130_fd_sc_hd__buf_2
X_4347_ _4374_/A0 _4374_/A1 _4352_/A vssd1 vssd1 vccd1 vccd1 _4347_/X sky130_fd_sc_hd__mux2_1
Xfanout336 _4328_/A vssd1 vssd1 vccd1 vccd1 _4323_/S sky130_fd_sc_hd__buf_2
Xfanout347 _4316_/A vssd1 vssd1 vccd1 vccd1 _4313_/S sky130_fd_sc_hd__clkbuf_4
XANTENNA_fanout393_A fanout398/X vssd1 vssd1 vccd1 vccd1 sky130_fd_sc_hd__diode_2
Xfanout325 _4794_/Q vssd1 vssd1 vccd1 vccd1 _4340_/A sky130_fd_sc_hd__clkbuf_2
Xfanout369 _3318_/B vssd1 vssd1 vccd1 vccd1 _3333_/B sky130_fd_sc_hd__buf_2
X_4278_ _4278_/A_N _4282_/B _4302_/C _4344_/A vssd1 vssd1 vccd1 vccd1 _4278_/X sky130_fd_sc_hd__and4b_1
Xfanout358 _3424_/A2 vssd1 vssd1 vccd1 vccd1 _3384_/A2 sky130_fd_sc_hd__buf_2
X_3229_ _4553_/Q _4594_/Q vssd1 vssd1 vccd1 vccd1 _3231_/A sky130_fd_sc_hd__nand2b_1
XTAP_TAPCELL_ROW_57_705 vssd1 vccd1 sky130_fd_sc_hd__tapvpwrvgnd_1
XFILLER_54_242 vssd1 vssd1 vccd1 vccd1 sky130_fd_sc_hd__fill_1
XTAP_TAPCELL_ROW_65_771 vssd1 vccd1 sky130_fd_sc_hd__tapvpwrvgnd_1
XFILLER_14_128 vssd1 vssd1 vccd1 vccd1 sky130_fd_sc_hd__fill_1
XFILLER_14_139 vssd1 vssd1 vccd1 vccd1 sky130_fd_sc_hd__fill_1
XFILLER_52_35 vssd1 vssd1 vccd1 vccd1 sky130_fd_sc_hd__fill_1
XANTENNA__4002__A2 _4022_/A2 vssd1 vssd1 vccd1 vccd1 sky130_fd_sc_hd__diode_2
XTAP_TAPCELL_ROW_20_373 vssd1 vccd1 sky130_fd_sc_hd__tapvpwrvgnd_1
XANTENNA_fanout94_X _4410_/S vssd1 vssd1 vccd1 vccd1 sky130_fd_sc_hd__diode_2
XANTENNA__4069__A2 _4105_/A2 vssd1 vssd1 vccd1 vccd1 sky130_fd_sc_hd__diode_2
XTAP_TAPCELL_ROW_28_440 vssd1 vccd1 sky130_fd_sc_hd__tapvpwrvgnd_1
XFILLER_60_245 vssd1 vssd1 vccd1 vccd1 sky130_fd_sc_hd__decap_6
XFILLER_9_165 vssd1 vssd1 vccd1 vccd1 sky130_fd_sc_hd__fill_1
XANTENNA_clkbuf_leaf_20_clk_A clkbuf_2_3__f_clk/X vssd1 vssd1 vccd1 vccd1 sky130_fd_sc_hd__diode_2
X_3580_ _3572_/A _3572_/B _3566_/Y _3561_/A _3567_/D vssd1 vssd1 vccd1 vccd1 _3580_/Y
+ sky130_fd_sc_hd__o221ai_4
X_2600_ _2599_/C _2599_/A _2599_/B vssd1 vssd1 vccd1 vccd1 _2601_/B sky130_fd_sc_hd__o21ai_1
X_2531_ _2530_/B _2531_/B vssd1 vssd1 vccd1 vccd1 _2532_/B sky130_fd_sc_hd__and2b_1
X_2462_ _4688_/Q _4675_/Q vssd1 vssd1 vccd1 vccd1 _2462_/Y sky130_fd_sc_hd__nand2_1
XFILLER_5_393 vssd1 vssd1 vccd1 vccd1 sky130_fd_sc_hd__fill_2
XANTENNA_clkbuf_leaf_35_clk_A clkload2/A vssd1 vssd1 vccd1 vccd1 sky130_fd_sc_hd__diode_2
X_4201_ _4200_/Y _4199_/X _4198_/X hold100/X _4205_/B2 vssd1 vssd1 vccd1 vccd1 _4742_/D
+ sky130_fd_sc_hd__o32a_1
XFILLER_47_3 vssd1 vssd1 vccd1 vccd1 sky130_fd_sc_hd__fill_1
X_2393_ _4564_/Q hold46/A _2419_/S vssd1 vssd1 vccd1 vccd1 _2393_/X sky130_fd_sc_hd__mux2_1
X_4132_ _4140_/A_N _4136_/B _4132_/C _4266_/D vssd1 vssd1 vccd1 vccd1 _4132_/X sky130_fd_sc_hd__and4b_1
XFILLER_68_367 vssd1 vssd1 vccd1 vccd1 sky130_fd_sc_hd__decap_6
X_4063_ _4099_/A0 _4083_/A1 _4063_/S vssd1 vssd1 vccd1 vccd1 _4063_/X sky130_fd_sc_hd__mux2_1
XTAP_TAPCELL_ROW_79_896 vssd1 vccd1 sky130_fd_sc_hd__tapvpwrvgnd_1
X_3014_ _3001_/X _3013_/Y _3157_/A2 vssd1 vssd1 vccd1 vccd1 _3014_/Y sky130_fd_sc_hd__o21ai_1
XFILLER_36_253 vssd1 vssd1 vccd1 vccd1 sky130_fd_sc_hd__decap_8
X_3916_ _4306_/B _4302_/C _3919_/B vssd1 vssd1 vccd1 vccd1 _3916_/X sky130_fd_sc_hd__or3b_1
XANTENNA_fanout141_A _3922_/B1 vssd1 vssd1 vccd1 vccd1 sky130_fd_sc_hd__diode_2
XANTENNA_fanout239_A _2271_/S vssd1 vssd1 vccd1 vccd1 sky130_fd_sc_hd__diode_2
XTAP_TAPCELL_ROW_34_498 vssd1 vccd1 sky130_fd_sc_hd__tapvpwrvgnd_1
X_3847_ _3056_/Y _3069_/Y _3070_/Y vssd1 vssd1 vccd1 vccd1 _3847_/Y sky130_fd_sc_hd__a21oi_1
XFILLER_22_38 vssd1 vssd1 vccd1 vccd1 sky130_fd_sc_hd__fill_1
X_3778_ _4537_/Q _4646_/Q vssd1 vssd1 vccd1 vccd1 _3778_/Y sky130_fd_sc_hd__nand2_1
X_2729_ _4758_/Q _4773_/Q vssd1 vssd1 vccd1 vccd1 _2785_/A sky130_fd_sc_hd__nand2_1
Xfanout122 _3890_/S vssd1 vssd1 vccd1 vccd1 _3886_/S sky130_fd_sc_hd__buf_2
Xfanout100 _3542_/X vssd1 vssd1 vccd1 vccd1 _3549_/A sky130_fd_sc_hd__clkbuf_4
Xfanout111 _2428_/Y vssd1 vssd1 vccd1 vccd1 _3828_/A2 sky130_fd_sc_hd__clkbuf_2
XFILLER_59_301 vccd1 vssd1 vccd1 vssd1 sky130_ef_sc_hd__decap_12
Xfanout155 _4241_/B2 vssd1 vssd1 vccd1 vccd1 _4240_/B1 sky130_fd_sc_hd__clkbuf_2
Xfanout133 _3995_/B2 vssd1 vssd1 vccd1 vccd1 _3999_/B2 sky130_fd_sc_hd__buf_2
Xfanout144 _4039_/B2 vssd1 vssd1 vccd1 vccd1 _4038_/B1 sky130_fd_sc_hd__buf_2
XFILLER_59_323 vssd1 vssd1 vccd1 vccd1 sky130_fd_sc_hd__fill_1
Xfanout177 _3897_/Y vssd1 vssd1 vccd1 vccd1 _4374_/A0 sky130_fd_sc_hd__clkbuf_2
Xfanout166 _4179_/X vssd1 vssd1 vccd1 vccd1 _4210_/A1 sky130_fd_sc_hd__buf_2
Xfanout188 _3033_/A vssd1 vssd1 vccd1 vccd1 _2975_/A sky130_fd_sc_hd__clkbuf_2
Xfanout199 _2424_/S vssd1 vssd1 vccd1 vccd1 _2426_/S sky130_fd_sc_hd__buf_2
XFILLER_47_518 vssd1 vssd1 vccd1 vccd1 sky130_fd_sc_hd__fill_1
XPHY_EDGE_ROW_29_Right_29 vssd1 vssd1 vccd1 vccd1 sky130_fd_sc_hd__decap_3
XTAP_TAPCELL_ROW_25_410 vssd1 vccd1 sky130_fd_sc_hd__tapvpwrvgnd_1
XFILLER_27_297 vssd1 vssd1 vccd1 vccd1 sky130_fd_sc_hd__decap_4
XPHY_EDGE_ROW_38_Right_38 vssd1 vssd1 vccd1 vccd1 sky130_fd_sc_hd__decap_3
XFILLER_10_153 vccd1 vssd1 vccd1 vssd1 sky130_ef_sc_hd__decap_12
XFILLER_2_363 vssd1 vssd1 vccd1 vccd1 sky130_fd_sc_hd__fill_1
XFILLER_77_153 vssd1 vssd1 vccd1 vccd1 sky130_fd_sc_hd__fill_1
XPHY_EDGE_ROW_47_Right_47 vssd1 vssd1 vccd1 vccd1 sky130_fd_sc_hd__decap_3
XFILLER_77_175 vccd1 vssd1 vccd1 vssd1 sky130_ef_sc_hd__decap_12
XANTENNA__3526__A2_N _3522_/A2 vssd1 vssd1 vccd1 vccd1 sky130_fd_sc_hd__diode_2
XFILLER_80_307 vssd1 vssd1 vccd1 vccd1 sky130_fd_sc_hd__fill_1
XTAP_TAPCELL_ROW_76_877 vssd1 vccd1 sky130_fd_sc_hd__tapvpwrvgnd_1
XFILLER_18_253 vssd1 vssd1 vccd1 vccd1 sky130_fd_sc_hd__decap_4
XFILLER_18_297 vssd1 vssd1 vccd1 vccd1 sky130_fd_sc_hd__decap_8
X_4750_ _4751_/CLK _4750_/D fanout395/X vssd1 vssd1 vccd1 vccd1 _4750_/Q sky130_fd_sc_hd__dfrtp_1
XPHY_EDGE_ROW_56_Right_56 vssd1 vssd1 vccd1 vccd1 sky130_fd_sc_hd__decap_3
X_4681_ _4702_/CLK _4681_/D fanout386/X vssd1 vssd1 vccd1 vccd1 _4681_/Q sky130_fd_sc_hd__dfrtp_1
XTAP_TAPCELL_ROW_31_468 vssd1 vccd1 sky130_fd_sc_hd__tapvpwrvgnd_1
X_3701_ _3701_/A _3709_/A _3725_/B vssd1 vssd1 vccd1 vccd1 _3701_/X sky130_fd_sc_hd__and3_1
X_3632_ _3643_/C _3632_/B vssd1 vssd1 vccd1 vccd1 _3632_/X sky130_fd_sc_hd__or2_1
X_3563_ hold217/X _3603_/S _3562_/X vssd1 vssd1 vccd1 vccd1 _4585_/D sky130_fd_sc_hd__a21o_1
X_3494_ _4611_/Q _3503_/A2 _3504_/B1 _3784_/A1 vssd1 vssd1 vccd1 vccd1 _3494_/X sky130_fd_sc_hd__o211a_1
X_2514_ _4691_/Q _4678_/Q vssd1 vssd1 vccd1 vccd1 _2514_/Y sky130_fd_sc_hd__nand2_1
XPHY_EDGE_ROW_65_Right_65 vssd1 vssd1 vccd1 vccd1 sky130_fd_sc_hd__decap_3
X_2445_ _2445_/A _2445_/B _4454_/Q vssd1 vssd1 vccd1 vccd1 _2445_/Y sky130_fd_sc_hd__nor3b_1
XANTENNA__3941__S _4063_/S vssd1 vssd1 vccd1 vccd1 sky130_fd_sc_hd__diode_2
X_4115_ _4167_/A0 _4171_/A1 _4120_/D vssd1 vssd1 vccd1 vccd1 _4115_/X sky130_fd_sc_hd__mux2_1
X_2376_ hold1/X _2375_/X _2382_/S vssd1 vssd1 vccd1 vccd1 _4483_/D sky130_fd_sc_hd__mux2_1
X_4046_ hold170/X _4058_/B2 _4043_/X _4045_/X vssd1 vssd1 vccd1 vccd1 _4703_/D sky130_fd_sc_hd__o22a_1
XFILLER_64_370 vssd1 vssd1 vccd1 vccd1 sky130_fd_sc_hd__fill_2
XPHY_EDGE_ROW_74_Right_74 vssd1 vssd1 vccd1 vccd1 sky130_fd_sc_hd__decap_3
XFILLER_12_418 vssd1 vssd1 vccd1 vccd1 sky130_fd_sc_hd__fill_2
XFILLER_24_289 vccd1 vssd1 vccd1 vssd1 sky130_ef_sc_hd__decap_12
XPHY_EDGE_ROW_83_Right_83 vssd1 vssd1 vccd1 vccd1 sky130_fd_sc_hd__decap_3
XFILLER_3_149 vccd1 vssd1 vccd1 vssd1 sky130_ef_sc_hd__decap_12
XANTENNA__4141__A1 _4274_/D vssd1 vssd1 vccd1 vccd1 sky130_fd_sc_hd__diode_2
XFILLER_58_89 vssd1 vssd1 vccd1 vccd1 sky130_fd_sc_hd__fill_1
XFILLER_59_142 vssd1 vssd1 vccd1 vccd1 sky130_fd_sc_hd__fill_1
XFILLER_87_495 vssd1 vssd1 vccd1 vccd1 sky130_fd_sc_hd__decap_8
XFILLER_74_112 vssd1 vssd1 vccd1 vccd1 sky130_fd_sc_hd__fill_1
XFILLER_74_101 vssd1 vssd1 vccd1 vccd1 sky130_fd_sc_hd__fill_1
XFILLER_59_197 vccd1 vssd1 vccd1 vssd1 sky130_ef_sc_hd__decap_12
XFILLER_74_178 vssd1 vssd1 vccd1 vccd1 sky130_fd_sc_hd__fill_2
XFILLER_62_329 vssd1 vssd1 vccd1 vccd1 sky130_fd_sc_hd__decap_8
XFILLER_15_201 vssd1 vssd1 vccd1 vccd1 sky130_fd_sc_hd__decap_3
XTAP_TAPCELL_ROW_73_847 vssd1 vccd1 sky130_fd_sc_hd__tapvpwrvgnd_1
XFILLER_15_223 vssd1 vssd1 vccd1 vccd1 sky130_fd_sc_hd__fill_1
XFILLER_15_278 vssd1 vssd1 vccd1 vccd1 sky130_fd_sc_hd__fill_2
XFILLER_7_422 vssd1 vssd1 vccd1 vccd1 sky130_fd_sc_hd__decap_8
XANTENNA__2930__A2 _2930_/A2 vssd1 vssd1 vccd1 vccd1 sky130_fd_sc_hd__diode_2
X_2230_ _4540_/Q _4581_/Q vssd1 vssd1 vccd1 vccd1 _2230_/X sky130_fd_sc_hd__and2b_1
XANTENNA_clkbuf_2_2__f_clk_A clkbuf_0_clk/X vssd1 vssd1 vccd1 vccd1 sky130_fd_sc_hd__diode_2
XFILLER_0_41 vssd1 vssd1 vccd1 vccd1 sky130_fd_sc_hd__decap_8
XTAP_TAPCELL_ROW_36_516 vssd1 vccd1 sky130_fd_sc_hd__tapvpwrvgnd_1
XFILLER_0_85 vssd1 vssd1 vccd1 vccd1 sky130_fd_sc_hd__fill_1
X_4802_ _4817_/CLK _4802_/D fanout397/X vssd1 vssd1 vccd1 vccd1 _4802_/Q sky130_fd_sc_hd__dfrtp_1
X_2994_ _2993_/C _2993_/A _3025_/A vssd1 vssd1 vccd1 vccd1 _2996_/D sky130_fd_sc_hd__o21ai_1
XTAP_TAPCELL_ROW_44_582 vssd1 vccd1 sky130_fd_sc_hd__tapvpwrvgnd_1
XANTENNA__3946__A1 _3946_/A1 vssd1 vssd1 vccd1 vccd1 sky130_fd_sc_hd__diode_2
X_4733_ _4748_/CLK _4733_/D fanout392/X vssd1 vssd1 vccd1 vccd1 hold92/A sky130_fd_sc_hd__dfrtp_1
X_4664_ _4744_/CLK _4664_/D fanout391/X vssd1 vssd1 vccd1 vccd1 _4664_/Q sky130_fd_sc_hd__dfrtp_2
X_3615_ _3613_/C _3613_/B _4593_/Q vssd1 vssd1 vccd1 vccd1 _3615_/X sky130_fd_sc_hd__a21o_1
X_4595_ _4597_/CLK _4595_/D fanout413/X vssd1 vssd1 vccd1 vccd1 _4595_/Q sky130_fd_sc_hd__dfrtp_1
X_3546_ _4582_/Q _3603_/S _3545_/X _3544_/Y vssd1 vssd1 vccd1 vccd1 _4582_/D sky130_fd_sc_hd__a22o_1
XANTENNA_fanout104_A _3534_/A2 vssd1 vssd1 vccd1 vccd1 sky130_fd_sc_hd__diode_2
X_3477_ _4608_/Q _3503_/A2 _3477_/B1 _3784_/A1 vssd1 vssd1 vccd1 vccd1 _3477_/X sky130_fd_sc_hd__o211a_1
XANTENNA__4123__A1 _4171_/A1 vssd1 vssd1 vccd1 vccd1 sky130_fd_sc_hd__diode_2
XANTENNA__3671__S _3735_/S vssd1 vssd1 vccd1 vccd1 sky130_fd_sc_hd__diode_2
X_2428_ _3613_/C _4666_/Q vssd1 vssd1 vccd1 vccd1 _2428_/Y sky130_fd_sc_hd__nand2_1
X_2359_ _4547_/Q hold35/A _2365_/S vssd1 vssd1 vccd1 vccd1 _2359_/X sky130_fd_sc_hd__mux2_1
XFILLER_84_432 vccd1 vssd1 vccd1 vssd1 sky130_ef_sc_hd__decap_12
X_4029_ _4104_/C _4037_/B _4033_/C _4029_/D vssd1 vssd1 vccd1 vccd1 _4029_/X sky130_fd_sc_hd__and4b_1
XFILLER_44_329 vssd1 vssd1 vccd1 vccd1 sky130_fd_sc_hd__decap_3
XTAP_TAPCELL_ROW_70_817 vssd1 vccd1 sky130_fd_sc_hd__tapvpwrvgnd_1
XFILLER_8_208 vssd1 vssd1 vccd1 vccd1 sky130_fd_sc_hd__decap_3
XANTENNA__3937__A1 _2274_/B vssd1 vssd1 vccd1 vccd1 sky130_fd_sc_hd__diode_2
XFILLER_8_219 vssd1 vssd1 vccd1 vccd1 sky130_fd_sc_hd__decap_3
XFILLER_4_425 vssd1 vssd1 vccd1 vccd1 sky130_fd_sc_hd__decap_4
XTAP_TAPCELL_ROW_7_252 vssd1 vccd1 sky130_fd_sc_hd__tapvpwrvgnd_1
XFILLER_87_281 vccd1 vssd1 vccd1 vssd1 sky130_ef_sc_hd__decap_12
XANTENNA_input34_A s_axis_tdata[9] vssd1 vssd1 vccd1 vccd1 sky130_fd_sc_hd__diode_2
XTAP_TAPCELL_ROW_86_961 vssd1 vccd1 sky130_fd_sc_hd__tapvpwrvgnd_1
XFILLER_85_98 vccd1 vssd1 vccd1 vssd1 sky130_ef_sc_hd__decap_12
XANTENNA__4128__D _4323_/S vssd1 vssd1 vccd1 vccd1 sky130_fd_sc_hd__diode_2
XFILLER_62_126 vssd1 vssd1 vccd1 vccd1 sky130_fd_sc_hd__fill_1
XFILLER_31_513 vssd1 vssd1 vccd1 vccd1 sky130_fd_sc_hd__fill_2
XFILLER_11_281 vssd1 vssd1 vccd1 vccd1 sky130_fd_sc_hd__decap_8
Xhold208 _4765_/Q vssd1 vssd1 vccd1 vccd1 hold208/X sky130_fd_sc_hd__dlygate4sd3_1
XANTENNA__4353__A1 _4352_/A vssd1 vssd1 vccd1 vccd1 sky130_fd_sc_hd__diode_2
XFILLER_7_296 vssd1 vssd1 vccd1 vccd1 sky130_fd_sc_hd__decap_6
X_4380_ _4120_/D input14/X _4400_/S vssd1 vssd1 vccd1 vccd1 _4789_/D sky130_fd_sc_hd__mux2_1
X_3400_ _4594_/Q _3424_/A2 _3541_/B1 _3925_/S vssd1 vssd1 vccd1 vccd1 _3400_/X sky130_fd_sc_hd__o211a_1
Xhold219 _4638_/Q vssd1 vssd1 vccd1 vccd1 hold219/X sky130_fd_sc_hd__dlygate4sd3_1
X_3331_ _4580_/Q _3333_/B vssd1 vssd1 vccd1 vccd1 _3331_/X sky130_fd_sc_hd__or2_1
XANTENNA__4105__A1 _4372_/A vssd1 vssd1 vccd1 vccd1 sky130_fd_sc_hd__diode_2
X_3262_ _4542_/Q _4583_/Q vssd1 vssd1 vccd1 vccd1 _3338_/A sky130_fd_sc_hd__nor2_1
X_2213_ _4735_/Q vssd1 vssd1 vccd1 vccd1 _2964_/B sky130_fd_sc_hd__inv_2
XFILLER_66_421 vssd1 vssd1 vccd1 vccd1 sky130_fd_sc_hd__decap_6
X_3193_ _4563_/Q _4604_/Q vssd1 vssd1 vccd1 vccd1 _3195_/A sky130_fd_sc_hd__and2_1
XTAP_TAPCELL_ROW_49_630 vssd1 vccd1 sky130_fd_sc_hd__tapvpwrvgnd_1
XFILLER_26_318 vssd1 vssd1 vccd1 vccd1 sky130_fd_sc_hd__decap_3
X_2977_ _2977_/A _2977_/B _2977_/C vssd1 vssd1 vccd1 vccd1 _2978_/B sky130_fd_sc_hd__and3_1
XANTENNA__4041__B1 _3975_/S vssd1 vssd1 vccd1 vccd1 sky130_fd_sc_hd__diode_2
X_4716_ _4745_/CLK _4716_/D fanout389/X vssd1 vssd1 vccd1 vccd1 _4716_/Q sky130_fd_sc_hd__dfrtp_1
X_4647_ _4647_/CLK _4647_/D fanout430/X vssd1 vssd1 vccd1 vccd1 _4647_/Q sky130_fd_sc_hd__dfrtp_1
XFILLER_30_49 vssd1 vssd1 vccd1 vccd1 sky130_fd_sc_hd__decap_6
X_4578_ _4580_/CLK _4578_/D fanout436/X vssd1 vssd1 vccd1 vccd1 _4578_/Q sky130_fd_sc_hd__dfrtp_2
X_3529_ _3536_/A2 _3531_/C _3528_/X _3536_/B1 vssd1 vssd1 vccd1 vccd1 _3529_/X sky130_fd_sc_hd__a31o_1
XFILLER_1_439 vssd1 vssd1 vccd1 vccd1 sky130_fd_sc_hd__fill_1
XANTENNA__4794__Q _4794_/Q vssd1 vssd1 vccd1 vccd1 sky130_fd_sc_hd__diode_2
XFILLER_39_47 vssd1 vssd1 vccd1 vccd1 sky130_fd_sc_hd__fill_1
XFILLER_76_229 vssd1 vssd1 vccd1 vccd1 sky130_fd_sc_hd__fill_2
XTAP_TAPCELL_ROW_4_222 vssd1 vccd1 sky130_fd_sc_hd__tapvpwrvgnd_1
XFILLER_69_281 vssd1 vssd1 vccd1 vccd1 sky130_fd_sc_hd__fill_1
XFILLER_84_251 vssd1 vssd1 vccd1 vccd1 sky130_fd_sc_hd__fill_1
XFILLER_72_402 vssd1 vssd1 vccd1 vccd1 sky130_fd_sc_hd__fill_1
XANTENNA__3870__A3 _2369_/S vssd1 vssd1 vccd1 vccd1 sky130_fd_sc_hd__diode_2
XTAP_TAPCELL_ROW_55_688 vssd1 vccd1 sky130_fd_sc_hd__tapvpwrvgnd_1
XANTENNA__2594__B1 _3870_/B1 vssd1 vssd1 vccd1 vccd1 sky130_fd_sc_hd__diode_2
XTAP_TAPCELL_ROW_10_279 vssd1 vccd1 sky130_fd_sc_hd__tapvpwrvgnd_1
XANTENNA__4099__A0 _4099_/A0 vssd1 vssd1 vccd1 vccd1 sky130_fd_sc_hd__diode_2
XFILLER_48_421 vssd1 vssd1 vccd1 vccd1 sky130_fd_sc_hd__decap_4
XFILLER_48_432 vccd1 vssd1 vccd1 vssd1 sky130_ef_sc_hd__decap_12
Xhold80 hold80/A vssd1 vssd1 vccd1 vccd1 hold80/X sky130_fd_sc_hd__dlygate4sd3_1
XTAP_TAPCELL_ROW_46_600 vssd1 vccd1 sky130_fd_sc_hd__tapvpwrvgnd_1
Xhold91 hold91/A vssd1 vssd1 vccd1 vccd1 hold91/X sky130_fd_sc_hd__dlygate4sd3_1
X_2900_ _3835_/A _3835_/B _4666_/Q _4377_/C1 vssd1 vssd1 vccd1 vccd1 _2900_/X sky130_fd_sc_hd__o211a_1
X_3880_ _4068_/B _4056_/D vssd1 vssd1 vccd1 vccd1 _4044_/B sky130_fd_sc_hd__or2_1
X_2831_ _2816_/X _2830_/Y _2985_/A2 vssd1 vssd1 vccd1 vccd1 _2831_/Y sky130_fd_sc_hd__o21ai_1
XFILLER_77_3 vssd1 vssd1 vccd1 vccd1 sky130_fd_sc_hd__fill_1
X_2762_ _4524_/Q _2797_/A2 _2747_/Y _2761_/Y vssd1 vssd1 vccd1 vccd1 _4524_/D sky130_fd_sc_hd__o22a_1
X_4501_ _4576_/CLK _4501_/D fanout438/X vssd1 vssd1 vccd1 vccd1 hold74/A sky130_fd_sc_hd__dfrtp_1
X_2693_ hold173/X _3870_/B1 _2675_/Y _2692_/X vssd1 vssd1 vccd1 vccd1 _4522_/D sky130_fd_sc_hd__o22a_1
X_4432_ _4562_/CLK _4432_/D _3923_/C vssd1 vssd1 vccd1 vccd1 hold72/A sky130_fd_sc_hd__dfrtp_1
X_4363_ _4374_/A0 _4374_/A1 _4368_/A vssd1 vssd1 vccd1 vccd1 _4363_/X sky130_fd_sc_hd__mux2_1
X_4294_ _4245_/D _4306_/B _4302_/C _4360_/A vssd1 vssd1 vccd1 vccd1 _4294_/X sky130_fd_sc_hd__and4b_1
X_3314_ _3511_/A _3511_/B _3314_/C vssd1 vssd1 vccd1 vccd1 _3316_/A sky130_fd_sc_hd__nand3_1
X_3245_ _4549_/Q _4590_/Q vssd1 vssd1 vccd1 vccd1 _3380_/A sky130_fd_sc_hd__nand2_1
XFILLER_58_229 vssd1 vssd1 vccd1 vccd1 sky130_fd_sc_hd__decap_3
X_3176_ _4566_/Q _4607_/Q vssd1 vssd1 vccd1 vccd1 _3301_/A sky130_fd_sc_hd__and2_1
XFILLER_54_402 vccd1 vssd1 vccd1 vssd1 sky130_ef_sc_hd__decap_12
XFILLER_81_221 vssd1 vssd1 vccd1 vccd1 sky130_fd_sc_hd__decap_3
XFILLER_26_115 vssd1 vssd1 vccd1 vccd1 sky130_fd_sc_hd__fill_1
XTAP_TAPCELL_ROW_80_912 vssd1 vccd1 sky130_fd_sc_hd__tapvpwrvgnd_1
XFILLER_22_321 vssd1 vssd1 vccd1 vccd1 sky130_fd_sc_hd__fill_1
XTAP_TAPCELL_ROW_52_658 vssd1 vccd1 sky130_fd_sc_hd__tapvpwrvgnd_1
XFILLER_22_365 vccd1 vssd1 vccd1 vssd1 sky130_ef_sc_hd__decap_12
XANTENNA_fanout224_X _4212_/A2 vssd1 vssd1 vccd1 vccd1 sky130_fd_sc_hd__diode_2
XANTENNA__4789__Q _4789_/Q vssd1 vssd1 vccd1 vccd1 sky130_fd_sc_hd__diode_2
XANTENNA__2869__A_N _4702_/Q vssd1 vssd1 vccd1 vccd1 sky130_fd_sc_hd__diode_2
XANTENNA__4317__A1 _4316_/A vssd1 vssd1 vccd1 vccd1 sky130_fd_sc_hd__diode_2
XFILLER_1_225 vssd1 vssd1 vccd1 vccd1 sky130_fd_sc_hd__decap_4
XFILLER_77_505 vssd1 vssd1 vccd1 vccd1 sky130_fd_sc_hd__fill_1
XANTENNA__4020__S _4087_/S vssd1 vssd1 vccd1 vccd1 sky130_fd_sc_hd__diode_2
XFILLER_57_262 vssd1 vssd1 vccd1 vccd1 sky130_fd_sc_hd__decap_3
XFILLER_72_210 vssd1 vssd1 vccd1 vccd1 sky130_fd_sc_hd__fill_1
XFILLER_72_232 vccd1 vssd1 vccd1 vssd1 sky130_ef_sc_hd__decap_12
XFILLER_72_265 vccd1 vssd1 vccd1 vssd1 sky130_ef_sc_hd__decap_12
XFILLER_13_310 vssd1 vssd1 vccd1 vccd1 sky130_fd_sc_hd__decap_3
XTAP_TAPCELL_ROW_15_327 vssd1 vccd1 sky130_fd_sc_hd__tapvpwrvgnd_1
XFILLER_15_60 vssd1 vssd1 vccd1 vccd1 sky130_fd_sc_hd__decap_3
XFILLER_13_387 vssd1 vssd1 vccd1 vccd1 sky130_fd_sc_hd__decap_4
XTAP_TAPCELL_ROW_23_393 vssd1 vccd1 sky130_fd_sc_hd__tapvpwrvgnd_1
XFILLER_31_81 vssd1 vssd1 vccd1 vccd1 sky130_fd_sc_hd__decap_8
Xoutput70 hold21/A vssd1 vssd1 vccd1 vccd1 m_axis_tdata[3] sky130_fd_sc_hd__buf_2
X_3030_ _4765_/Q _4780_/Q _3033_/A _3008_/B vssd1 vssd1 vccd1 vccd1 _3037_/A sky130_fd_sc_hd__a31o_1
XANTENNA__3989__B _4001_/B vssd1 vssd1 vccd1 vccd1 sky130_fd_sc_hd__diode_2
XFILLER_48_262 vccd1 vssd1 vccd1 vssd1 sky130_ef_sc_hd__decap_12
XFILLER_51_438 vssd1 vssd1 vccd1 vccd1 sky130_fd_sc_hd__fill_1
X_3932_ _3872_/X _3971_/A1 _3984_/S vssd1 vssd1 vccd1 vccd1 _3932_/X sky130_fd_sc_hd__mux2_1
Xclkbuf_leaf_43_clk clkload2/A vssd1 vssd1 vccd1 vccd1 _4593_/CLK sky130_fd_sc_hd__clkbuf_8
XFILLER_51_449 vccd1 vssd1 vccd1 vssd1 sky130_ef_sc_hd__decap_12
X_3863_ _3862_/A _3863_/A2 _3862_/C _3862_/D vssd1 vssd1 vccd1 vccd1 _3864_/B sky130_fd_sc_hd__a22o_1
XANTENNA_clkbuf_leaf_9_clk_A clkload1/A vssd1 vssd1 vccd1 vccd1 sky130_fd_sc_hd__diode_2
X_2814_ _2814_/A _2814_/B vssd1 vssd1 vccd1 vccd1 _2816_/B sky130_fd_sc_hd__or2_1
X_3794_ _3794_/A0 hold37/X _3925_/S vssd1 vssd1 vccd1 vccd1 _4615_/D sky130_fd_sc_hd__mux2_1
XANTENNA__3942__A1_N _4332_/A vssd1 vssd1 vccd1 vccd1 sky130_fd_sc_hd__diode_2
XANTENNA__3944__S _4005_/D vssd1 vssd1 vccd1 vccd1 sky130_fd_sc_hd__diode_2
X_2745_ _2745_/A _2745_/B vssd1 vssd1 vccd1 vccd1 _2746_/B sky130_fd_sc_hd__nand2_1
X_2676_ _4725_/Q _2637_/B _2636_/A vssd1 vssd1 vccd1 vccd1 _2676_/Y sky130_fd_sc_hd__a21oi_1
X_4415_ _4546_/CLK _4415_/D fanout418/X vssd1 vssd1 vccd1 vccd1 hold45/A sky130_fd_sc_hd__dfrtp_1
Xfanout304 _4364_/A vssd1 vssd1 vccd1 vccd1 _4231_/C sky130_fd_sc_hd__buf_2
XANTENNA__3522__A2 _3522_/A2 vssd1 vssd1 vccd1 vccd1 sky130_fd_sc_hd__diode_2
X_4346_ _4779_/Q _4358_/A2 _4343_/X _4345_/X vssd1 vssd1 vccd1 vccd1 _4779_/D sky130_fd_sc_hd__o22a_1
Xfanout337 _4791_/Q vssd1 vssd1 vccd1 vccd1 _4328_/A sky130_fd_sc_hd__buf_2
Xfanout348 _4788_/Q vssd1 vssd1 vccd1 vccd1 _4316_/A sky130_fd_sc_hd__buf_2
Xfanout326 _4794_/Q vssd1 vssd1 vccd1 vccd1 _4005_/D sky130_fd_sc_hd__buf_2
Xfanout315 _4797_/Q vssd1 vssd1 vccd1 vccd1 _4017_/D sky130_fd_sc_hd__buf_2
XFILLER_59_505 vssd1 vssd1 vccd1 vccd1 sky130_fd_sc_hd__fill_1
X_4277_ _4305_/A0 _4281_/A1 _4348_/A vssd1 vssd1 vccd1 vccd1 _4277_/X sky130_fd_sc_hd__mux2_1
XANTENNA_fanout386_A fanout388/X vssd1 vssd1 vccd1 vccd1 sky130_fd_sc_hd__diode_2
Xfanout359 _3794_/A0 vssd1 vssd1 vccd1 vccd1 _3424_/A2 sky130_fd_sc_hd__buf_2
X_3228_ _4553_/Q _4594_/Q vssd1 vssd1 vccd1 vccd1 _3228_/Y sky130_fd_sc_hd__nand2_1
XFILLER_39_251 vssd1 vssd1 vccd1 vccd1 sky130_fd_sc_hd__fill_2
XTAP_TAPCELL_ROW_57_706 vssd1 vccd1 sky130_fd_sc_hd__tapvpwrvgnd_1
XFILLER_39_273 vssd1 vssd1 vccd1 vccd1 sky130_fd_sc_hd__decap_6
X_3159_ _2230_/X _3158_/Y _2249_/S vssd1 vssd1 vccd1 vccd1 _4539_/D sky130_fd_sc_hd__o21ba_1
XTAP_TAPCELL_ROW_65_772 vssd1 vccd1 sky130_fd_sc_hd__tapvpwrvgnd_1
XANTENNA_fanout341_X _4253_/S vssd1 vssd1 vccd1 vccd1 sky130_fd_sc_hd__diode_2
Xclkbuf_leaf_34_clk clkload2/A vssd1 vssd1 vccd1 vccd1 _4597_/CLK sky130_fd_sc_hd__clkbuf_8
XFILLER_22_184 vssd1 vssd1 vccd1 vccd1 sky130_fd_sc_hd__fill_1
XFILLER_2_501 vssd1 vssd1 vccd1 vccd1 sky130_fd_sc_hd__decap_8
XFILLER_77_88 vccd1 vssd1 vccd1 vssd1 sky130_ef_sc_hd__decap_12
XTAP_TAPCELL_ROW_28_441 vssd1 vccd1 sky130_fd_sc_hd__tapvpwrvgnd_1
XANTENNA__4136__D _4203_/C vssd1 vssd1 vccd1 vccd1 sky130_fd_sc_hd__diode_2
Xclkbuf_leaf_25_clk clkbuf_2_3__f_clk/X vssd1 vssd1 vccd1 vccd1 _4575_/CLK sky130_fd_sc_hd__clkbuf_8
XFILLER_9_111 vssd1 vssd1 vccd1 vccd1 sky130_fd_sc_hd__fill_1
XFILLER_9_144 vssd1 vssd1 vccd1 vccd1 sky130_fd_sc_hd__fill_1
X_2530_ _2531_/B _2530_/B vssd1 vssd1 vccd1 vccd1 _2554_/A sky130_fd_sc_hd__and2b_1
X_2461_ hold186/X _3806_/A2 _2460_/Y vssd1 vssd1 vccd1 vccd1 _4513_/D sky130_fd_sc_hd__o21a_1
XANTENNA__3504__A2 _3504_/A2 vssd1 vssd1 vccd1 vccd1 sky130_fd_sc_hd__diode_2
X_4200_ _4266_/D _4212_/A2 _4205_/B2 vssd1 vssd1 vccd1 vccd1 _4200_/Y sky130_fd_sc_hd__o21ai_1
X_2392_ hold33/X _2391_/X _2426_/S vssd1 vssd1 vccd1 vccd1 _4491_/D sky130_fd_sc_hd__mux2_1
XFILLER_68_335 vssd1 vssd1 vccd1 vccd1 sky130_fd_sc_hd__fill_1
X_4131_ _4167_/A0 _4171_/A1 _4203_/C vssd1 vssd1 vccd1 vccd1 _4131_/X sky130_fd_sc_hd__mux2_1
XFILLER_83_305 vssd1 vssd1 vccd1 vccd1 sky130_fd_sc_hd__fill_1
X_4062_ _4061_/Y _4060_/X _4059_/X hold151/X _4122_/B1 vssd1 vssd1 vccd1 vccd1 _4707_/D
+ sky130_fd_sc_hd__o32a_1
XTAP_TAPCELL_ROW_79_897 vssd1 vccd1 sky130_fd_sc_hd__tapvpwrvgnd_1
X_3013_ _3028_/B _3013_/B vssd1 vssd1 vccd1 vccd1 _3013_/Y sky130_fd_sc_hd__nand2_1
Xclkbuf_leaf_16_clk clkload1/A vssd1 vssd1 vccd1 vccd1 _4782_/CLK sky130_fd_sc_hd__clkbuf_8
X_3915_ _4193_/B2 _4212_/A2 _3914_/Y vssd1 vssd1 vccd1 vccd1 _4663_/D sky130_fd_sc_hd__a21oi_1
XFILLER_51_279 vssd1 vssd1 vccd1 vccd1 sky130_fd_sc_hd__fill_1
XTAP_TAPCELL_ROW_34_499 vssd1 vccd1 sky130_fd_sc_hd__tapvpwrvgnd_1
X_3846_ hold129/X _3848_/A2 _3845_/Y vssd1 vssd1 vccd1 vccd1 _4641_/D sky130_fd_sc_hd__a21o_1
X_3777_ _4536_/Q _4645_/Q _3776_/X _3768_/Y vssd1 vssd1 vccd1 vccd1 _3777_/Y sky130_fd_sc_hd__o22ai_1
XANTENNA_fanout301_A _4368_/A vssd1 vssd1 vccd1 vccd1 sky130_fd_sc_hd__diode_2
X_2728_ _2722_/A _2722_/C _2722_/B vssd1 vssd1 vccd1 vccd1 _2748_/B sky130_fd_sc_hd__o21ba_1
X_2659_ _4657_/Q _4756_/Q vssd1 vssd1 vccd1 vccd1 _2659_/Y sky130_fd_sc_hd__nor2_1
Xfanout101 _3542_/X vssd1 vssd1 vccd1 vccd1 _3792_/A2 sky130_fd_sc_hd__clkbuf_1
Xfanout112 _2428_/Y vssd1 vssd1 vccd1 vccd1 _3848_/A2 sky130_fd_sc_hd__buf_2
XFILLER_86_121 vssd1 vssd1 vccd1 vccd1 sky130_fd_sc_hd__decap_8
Xfanout156 _4358_/A2 vssd1 vssd1 vccd1 vccd1 _4295_/B1 sky130_fd_sc_hd__clkbuf_2
XANTENNA_fanout291_X _4001_/C vssd1 vssd1 vccd1 vccd1 sky130_fd_sc_hd__diode_2
Xfanout123 _3928_/S vssd1 vssd1 vccd1 vccd1 _3900_/B sky130_fd_sc_hd__clkbuf_2
Xfanout134 _2321_/B2 vssd1 vssd1 vccd1 vccd1 _3995_/B2 sky130_fd_sc_hd__buf_2
Xfanout145 _3922_/B1 vssd1 vssd1 vccd1 vccd1 _4039_/B2 sky130_fd_sc_hd__clkbuf_2
X_4329_ _4328_/A _4344_/B _4338_/A2 vssd1 vssd1 vccd1 vccd1 _4329_/Y sky130_fd_sc_hd__o21ai_1
XFILLER_59_346 vssd1 vssd1 vccd1 vccd1 sky130_fd_sc_hd__decap_8
Xfanout167 _4179_/X vssd1 vssd1 vccd1 vccd1 _4238_/A1 sky130_fd_sc_hd__clkbuf_2
Xfanout178 _3893_/X vssd1 vssd1 vccd1 vccd1 _4281_/A0 sky130_fd_sc_hd__clkbuf_2
Xfanout189 _3004_/B1 vssd1 vssd1 vccd1 vccd1 _3033_/A sky130_fd_sc_hd__buf_2
XFILLER_63_13 vssd1 vssd1 vccd1 vccd1 sky130_fd_sc_hd__decap_3
XFILLER_15_405 vssd1 vssd1 vccd1 vccd1 sky130_fd_sc_hd__fill_2
XFILLER_27_265 vssd1 vssd1 vccd1 vccd1 sky130_fd_sc_hd__fill_1
XTAP_TAPCELL_ROW_25_411 vssd1 vccd1 sky130_fd_sc_hd__tapvpwrvgnd_1
XFILLER_42_213 vssd1 vssd1 vccd1 vccd1 sky130_fd_sc_hd__decap_6
XANTENNA__3982__A2 _4022_/A2 vssd1 vssd1 vccd1 vccd1 sky130_fd_sc_hd__diode_2
XFILLER_10_165 vssd1 vssd1 vccd1 vccd1 sky130_fd_sc_hd__decap_4
XFILLER_12_61 vssd1 vssd1 vccd1 vccd1 sky130_fd_sc_hd__fill_1
XFILLER_10_187 vssd1 vssd1 vccd1 vccd1 sky130_fd_sc_hd__fill_1
XFILLER_2_320 vssd1 vssd1 vccd1 vccd1 sky130_fd_sc_hd__decap_3
XFILLER_73_371 vssd1 vssd1 vccd1 vccd1 sky130_fd_sc_hd__decap_8
XFILLER_21_408 vssd1 vssd1 vccd1 vccd1 sky130_fd_sc_hd__fill_1
XFILLER_33_279 vssd1 vssd1 vccd1 vccd1 sky130_fd_sc_hd__fill_1
XFILLER_14_471 vssd1 vssd1 vccd1 vccd1 sky130_fd_sc_hd__decap_4
X_3700_ _3729_/A _3700_/B vssd1 vssd1 vccd1 vccd1 _3725_/B sky130_fd_sc_hd__nand2b_1
X_4680_ clkload5/A _4680_/D fanout381/X vssd1 vssd1 vccd1 vccd1 _4680_/Q sky130_fd_sc_hd__dfrtp_1
X_3631_ _3657_/A _3657_/C vssd1 vssd1 vccd1 vccd1 _3632_/B sky130_fd_sc_hd__nand2_1
XTAP_TAPCELL_ROW_31_469 vssd1 vccd1 sky130_fd_sc_hd__tapvpwrvgnd_1
X_3562_ _4619_/Q _3567_/B _3561_/X vssd1 vssd1 vccd1 vccd1 _3562_/X sky130_fd_sc_hd__o21a_1
X_2513_ _4691_/Q _4678_/Q vssd1 vssd1 vccd1 vccd1 _2516_/C sky130_fd_sc_hd__and2_1
X_3493_ _3536_/A2 _3491_/Y _3492_/X _3536_/B1 vssd1 vssd1 vccd1 vccd1 _3493_/X sky130_fd_sc_hd__a31o_1
X_2444_ _4686_/Q _4673_/Q vssd1 vssd1 vccd1 vccd1 _2445_/B sky130_fd_sc_hd__nor2_1
Xclkbuf_leaf_5_clk clkload0/A vssd1 vssd1 vccd1 vccd1 clkload8/A sky130_fd_sc_hd__clkbuf_8
X_2375_ _4555_/Q hold14/A _2381_/S vssd1 vssd1 vccd1 vccd1 _2375_/X sky130_fd_sc_hd__mux2_1
X_4114_ _4720_/Q _4122_/B1 _4110_/Y _4113_/X vssd1 vssd1 vccd1 vccd1 _4720_/D sky130_fd_sc_hd__o22a_1
XFILLER_83_113 vssd1 vssd1 vccd1 vccd1 sky130_fd_sc_hd__fill_2
X_4045_ _4116_/B _4083_/A1 _3886_/S vssd1 vssd1 vccd1 vccd1 _4045_/X sky130_fd_sc_hd__a21o_1
XTAP_TAPCELL_ROW_39_536 vssd1 vccd1 sky130_fd_sc_hd__tapvpwrvgnd_1
XFILLER_33_49 vssd1 vssd1 vccd1 vccd1 sky130_fd_sc_hd__decap_6
XANTENNA__3413__A1 _3423_/A1 vssd1 vssd1 vccd1 vccd1 sky130_fd_sc_hd__diode_2
XPHY_EDGE_ROW_49_Left_137 vssd1 vssd1 vccd1 vccd1 sky130_fd_sc_hd__decap_3
X_3829_ _2783_/X _2795_/Y _2796_/Y vssd1 vssd1 vccd1 vccd1 _3829_/Y sky130_fd_sc_hd__a21oi_1
XANTENNA_fanout304_X _4231_/C vssd1 vssd1 vccd1 vccd1 sky130_fd_sc_hd__diode_2
XANTENNA__4797__Q _4797_/Q vssd1 vssd1 vccd1 vccd1 sky130_fd_sc_hd__diode_2
XFILLER_3_106 vssd1 vssd1 vccd1 vccd1 sky130_fd_sc_hd__decap_6
XANTENNA__4141__A2 _4176_/A2 vssd1 vssd1 vccd1 vccd1 sky130_fd_sc_hd__diode_2
XPHY_EDGE_ROW_58_Left_146 vssd1 vssd1 vccd1 vccd1 sky130_fd_sc_hd__decap_3
XFILLER_47_327 vssd1 vssd1 vccd1 vccd1 sky130_fd_sc_hd__fill_1
XTAP_TAPCELL_ROW_73_848 vssd1 vccd1 sky130_fd_sc_hd__tapvpwrvgnd_1
XFILLER_70_341 vccd1 vssd1 vccd1 vssd1 sky130_ef_sc_hd__decap_12
XPHY_EDGE_ROW_67_Left_155 vssd1 vssd1 vccd1 vccd1 sky130_fd_sc_hd__decap_3
XFILLER_30_205 vssd1 vssd1 vccd1 vccd1 sky130_fd_sc_hd__fill_1
XANTENNA_clkbuf_leaf_34_clk_A clkload2/A vssd1 vssd1 vccd1 vccd1 sky130_fd_sc_hd__diode_2
XFILLER_30_238 vssd1 vssd1 vccd1 vccd1 sky130_fd_sc_hd__decap_6
XFILLER_23_82 vssd1 vssd1 vccd1 vccd1 sky130_fd_sc_hd__fill_1
XANTENNA_clkbuf_leaf_49_clk_A clkload0/A vssd1 vssd1 vccd1 vccd1 sky130_fd_sc_hd__diode_2
XPHY_EDGE_ROW_76_Left_164 vssd1 vssd1 vccd1 vccd1 sky130_fd_sc_hd__decap_3
XFILLER_65_113 vssd1 vssd1 vccd1 vccd1 sky130_fd_sc_hd__decap_8
XFILLER_38_316 vccd1 vssd1 vccd1 vssd1 sky130_ef_sc_hd__decap_12
XANTENNA__3997__B _4001_/B vssd1 vssd1 vccd1 vccd1 sky130_fd_sc_hd__diode_2
XTAP_TAPCELL_ROW_36_517 vssd1 vccd1 sky130_fd_sc_hd__tapvpwrvgnd_1
XANTENNA__2393__S _2419_/S vssd1 vssd1 vccd1 vccd1 sky130_fd_sc_hd__diode_2
XPHY_EDGE_ROW_85_Left_173 vssd1 vssd1 vccd1 vccd1 sky130_fd_sc_hd__decap_3
XFILLER_61_352 vssd1 vssd1 vccd1 vccd1 sky130_fd_sc_hd__fill_1
X_4801_ _4817_/CLK _4801_/D fanout397/X vssd1 vssd1 vccd1 vccd1 _4801_/Q sky130_fd_sc_hd__dfrtp_1
X_2993_ _2993_/A _3025_/A _2993_/C vssd1 vssd1 vccd1 vccd1 _2996_/C sky130_fd_sc_hd__or3_1
XFILLER_21_227 vssd1 vssd1 vccd1 vccd1 sky130_fd_sc_hd__fill_1
XTAP_TAPCELL_ROW_44_583 vssd1 vccd1 sky130_fd_sc_hd__tapvpwrvgnd_1
X_4732_ _4748_/CLK _4732_/D fanout392/X vssd1 vssd1 vccd1 vccd1 hold85/A sky130_fd_sc_hd__dfrtp_1
XANTENNA__3946__A2 _3946_/A2 vssd1 vssd1 vccd1 vccd1 sky130_fd_sc_hd__diode_2
X_4663_ clkload7/A _4663_/D fanout381/X vssd1 vssd1 vccd1 vccd1 _4663_/Q sky130_fd_sc_hd__dfrtp_1
X_3614_ _4592_/Q _3655_/S _3613_/X _3610_/Y vssd1 vssd1 vccd1 vccd1 _4592_/D sky130_fd_sc_hd__a22o_1
X_4594_ _4597_/CLK _4594_/D fanout413/X vssd1 vssd1 vccd1 vccd1 _4594_/Q sky130_fd_sc_hd__dfrtp_1
X_3545_ _4509_/Q _4616_/Q _3613_/B _3561_/C vssd1 vssd1 vccd1 vccd1 _3545_/X sky130_fd_sc_hd__o211a_1
X_3476_ _3536_/A2 _3474_/X _3475_/X _3536_/B1 vssd1 vssd1 vccd1 vccd1 _3476_/X sky130_fd_sc_hd__a31o_1
X_2427_ _3561_/C _4666_/Q vssd1 vssd1 vccd1 vccd1 _2427_/X sky130_fd_sc_hd__and2_1
XANTENNA_fanout299_A _4802_/Q vssd1 vssd1 vccd1 vccd1 sky130_fd_sc_hd__diode_2
XFILLER_69_474 vssd1 vssd1 vccd1 vccd1 sky130_fd_sc_hd__decap_4
X_2358_ hold20/X _2357_/X _2366_/S vssd1 vssd1 vccd1 vccd1 _4474_/D sky130_fd_sc_hd__mux2_1
XFILLER_29_305 vssd1 vssd1 vccd1 vccd1 sky130_fd_sc_hd__decap_6
XFILLER_84_444 vccd1 vssd1 vccd1 vssd1 sky130_ef_sc_hd__decap_12
X_2289_ hold180/X _3983_/B2 _2288_/X _2286_/X vssd1 vssd1 vccd1 vccd1 _4454_/D sky130_fd_sc_hd__o22a_1
XFILLER_28_49 vccd1 vssd1 vccd1 vssd1 sky130_ef_sc_hd__decap_12
XFILLER_84_477 vccd1 vssd1 vccd1 vssd1 sky130_ef_sc_hd__decap_12
X_4028_ _4036_/A0 _4036_/A1 _4033_/D vssd1 vssd1 vccd1 vccd1 _4028_/X sky130_fd_sc_hd__mux2_1
XFILLER_37_393 vccd1 vssd1 vccd1 vssd1 sky130_ef_sc_hd__decap_12
XTAP_TAPCELL_ROW_70_818 vssd1 vccd1 sky130_fd_sc_hd__tapvpwrvgnd_1
XFILLER_64_190 vssd1 vssd1 vccd1 vccd1 sky130_fd_sc_hd__decap_6
XFILLER_12_227 vccd1 vssd1 vccd1 vssd1 sky130_ef_sc_hd__decap_12
XFILLER_52_385 vssd1 vssd1 vccd1 vccd1 sky130_fd_sc_hd__fill_2
XANTENNA__4033__A_N _4104_/C vssd1 vssd1 vccd1 vccd1 sky130_fd_sc_hd__diode_2
XTAP_TAPCELL_ROW_7_253 vssd1 vccd1 sky130_fd_sc_hd__tapvpwrvgnd_1
XFILLER_47_113 vssd1 vssd1 vccd1 vccd1 sky130_fd_sc_hd__fill_1
XFILLER_87_293 vccd1 vssd1 vccd1 vssd1 sky130_ef_sc_hd__decap_12
XANTENNA_input27_A s_axis_tdata[31] vssd1 vssd1 vccd1 vccd1 sky130_fd_sc_hd__diode_2
XFILLER_85_55 vssd1 vssd1 vccd1 vccd1 sky130_fd_sc_hd__fill_1
XANTENNA__4183__A_N _4258_/C vssd1 vssd1 vccd1 vccd1 sky130_fd_sc_hd__diode_2
XTAP_TAPCELL_ROW_86_962 vssd1 vccd1 sky130_fd_sc_hd__tapvpwrvgnd_1
XANTENNA__4144__D _4273_/S vssd1 vssd1 vccd1 vccd1 sky130_fd_sc_hd__diode_2
XFILLER_7_242 vssd1 vssd1 vccd1 vccd1 sky130_fd_sc_hd__decap_8
Xhold209 _4773_/Q vssd1 vssd1 vccd1 vccd1 hold209/X sky130_fd_sc_hd__dlygate4sd3_1
X_3330_ _3535_/C _3535_/D _3535_/A _3535_/B vssd1 vssd1 vccd1 vccd1 _3330_/X sky130_fd_sc_hd__a22o_1
X_3261_ _4543_/Q _4584_/Q vssd1 vssd1 vccd1 vccd1 _3261_/Y sky130_fd_sc_hd__nand2_1
XANTENNA__4105__A2 _4105_/A2 vssd1 vssd1 vccd1 vccd1 sky130_fd_sc_hd__diode_2
X_2212_ _4622_/Q vssd1 vssd1 vccd1 vccd1 _3578_/B sky130_fd_sc_hd__inv_2
XFILLER_22_3 vssd1 vssd1 vccd1 vccd1 sky130_fd_sc_hd__decap_4
X_3192_ _4564_/Q _4605_/Q vssd1 vssd1 vccd1 vccd1 _3458_/B sky130_fd_sc_hd__xor2_1
XFILLER_78_282 vccd1 vssd1 vccd1 vssd1 sky130_ef_sc_hd__decap_12
XTAP_TAPCELL_ROW_49_631 vssd1 vccd1 sky130_fd_sc_hd__tapvpwrvgnd_1
XFILLER_81_447 vssd1 vssd1 vccd1 vccd1 sky130_fd_sc_hd__fill_1
XANTENNA__4426__RESET_B fanout423/X vssd1 vssd1 vccd1 vccd1 sky130_fd_sc_hd__diode_2
XFILLER_46_190 vssd1 vssd1 vccd1 vccd1 sky130_fd_sc_hd__decap_6
XFILLER_34_374 vssd1 vssd1 vccd1 vccd1 sky130_fd_sc_hd__fill_2
X_2976_ _2977_/B _2977_/C _2977_/A vssd1 vssd1 vccd1 vccd1 _2978_/A sky130_fd_sc_hd__a21oi_1
XANTENNA__4041__A1 _4036_/S vssd1 vssd1 vccd1 vccd1 sky130_fd_sc_hd__diode_2
X_4715_ _4745_/CLK _4715_/D fanout389/X vssd1 vssd1 vccd1 vccd1 hold93/A sky130_fd_sc_hd__dfrtp_1
X_4646_ _4647_/CLK _4646_/D fanout430/X vssd1 vssd1 vccd1 vccd1 _4646_/Q sky130_fd_sc_hd__dfrtp_1
X_4577_ _4577_/CLK _4577_/D fanout437/X vssd1 vssd1 vccd1 vccd1 _4577_/Q sky130_fd_sc_hd__dfrtp_1
X_3528_ _3528_/A _3528_/B vssd1 vssd1 vccd1 vccd1 _3528_/X sky130_fd_sc_hd__or2_1
XANTENNA__2298__S _4063_/S vssd1 vssd1 vccd1 vccd1 sky130_fd_sc_hd__diode_2
X_3459_ _3451_/Y _3203_/B _3197_/X _3195_/A _3458_/B vssd1 vssd1 vccd1 vccd1 _3459_/X
+ sky130_fd_sc_hd__a311o_1
XFILLER_69_260 vssd1 vssd1 vccd1 vccd1 sky130_fd_sc_hd__fill_1
XTAP_TAPCELL_ROW_4_223 vssd1 vccd1 sky130_fd_sc_hd__tapvpwrvgnd_1
XTAP_TAPCELL_ROW_83_932 vssd1 vccd1 sky130_fd_sc_hd__tapvpwrvgnd_1
XFILLER_72_425 vssd1 vssd1 vccd1 vccd1 sky130_fd_sc_hd__decap_8
XANTENNA__2327__A _4087_/S vssd1 vssd1 vccd1 vccd1 sky130_fd_sc_hd__diode_2
XFILLER_44_149 vssd1 vssd1 vccd1 vccd1 sky130_fd_sc_hd__decap_3
XFILLER_9_518 vssd1 vssd1 vccd1 vccd1 sky130_fd_sc_hd__fill_1
XFILLER_20_50 vccd1 vssd1 vccd1 vssd1 sky130_ef_sc_hd__decap_12
XFILLER_20_83 vssd1 vssd1 vccd1 vccd1 sky130_fd_sc_hd__fill_1
XFILLER_0_473 vssd1 vssd1 vccd1 vccd1 sky130_fd_sc_hd__decap_3
XFILLER_48_411 vssd1 vssd1 vccd1 vccd1 sky130_fd_sc_hd__fill_1
XFILLER_48_444 vccd1 vssd1 vccd1 vssd1 sky130_ef_sc_hd__decap_12
Xhold92 hold92/A vssd1 vssd1 vccd1 vccd1 hold92/X sky130_fd_sc_hd__dlygate4sd3_1
Xhold81 hold81/A vssd1 vssd1 vccd1 vccd1 hold81/X sky130_fd_sc_hd__dlygate4sd3_1
Xhold70 hold70/A vssd1 vssd1 vccd1 vccd1 hold70/X sky130_fd_sc_hd__dlygate4sd3_1
XFILLER_63_447 vssd1 vssd1 vccd1 vccd1 sky130_fd_sc_hd__fill_1
XFILLER_63_425 vssd1 vssd1 vccd1 vccd1 sky130_fd_sc_hd__decap_3
XTAP_TAPCELL_ROW_46_601 vssd1 vccd1 sky130_fd_sc_hd__tapvpwrvgnd_1
XTAP_TAPCELL_ROW_18_347 vssd1 vccd1 sky130_fd_sc_hd__tapvpwrvgnd_1
XFILLER_43_160 vssd1 vssd1 vccd1 vccd1 sky130_fd_sc_hd__decap_8
XFILLER_45_91 vccd1 vssd1 vccd1 vssd1 sky130_ef_sc_hd__decap_12
XFILLER_31_322 vssd1 vssd1 vccd1 vccd1 sky130_fd_sc_hd__decap_3
X_2830_ _2850_/B _2830_/B vssd1 vssd1 vccd1 vccd1 _2830_/Y sky130_fd_sc_hd__nand2_1
X_2761_ _2749_/Y _2760_/X _2797_/A2 vssd1 vssd1 vccd1 vccd1 _2761_/Y sky130_fd_sc_hd__o21ai_1
X_4500_ _4575_/CLK _4500_/D fanout436/X vssd1 vssd1 vccd1 vccd1 hold52/A sky130_fd_sc_hd__dfrtp_1
XANTENNA__3782__B1 _3741_/S vssd1 vssd1 vccd1 vccd1 sky130_fd_sc_hd__diode_2
X_2692_ _3823_/A _3823_/B _3830_/A2 vssd1 vssd1 vccd1 vccd1 _2692_/X sky130_fd_sc_hd__a21o_1
X_4431_ _4562_/CLK _4431_/D _3923_/C vssd1 vssd1 vccd1 vccd1 hold73/A sky130_fd_sc_hd__dfrtp_1
XANTENNA__4326__A2 _4338_/A2 vssd1 vssd1 vccd1 vccd1 sky130_fd_sc_hd__diode_2
X_4362_ _4783_/Q _4378_/B2 _4359_/X _4361_/X vssd1 vssd1 vccd1 vccd1 _4783_/D sky130_fd_sc_hd__o22a_1
X_4293_ _4305_/A0 _4305_/A1 _4364_/A vssd1 vssd1 vccd1 vccd1 _4293_/X sky130_fd_sc_hd__mux2_1
X_3313_ _3511_/C _3313_/B _3516_/A _3313_/D vssd1 vssd1 vccd1 vccd1 _3314_/C sky130_fd_sc_hd__and4_1
X_3244_ _4550_/Q _4591_/Q vssd1 vssd1 vccd1 vccd1 _3279_/B sky130_fd_sc_hd__nand2_1
X_3175_ _4569_/Q _4610_/Q vssd1 vssd1 vccd1 vccd1 _3487_/B sky130_fd_sc_hd__xor2_2
XFILLER_54_414 vssd1 vssd1 vccd1 vccd1 sky130_fd_sc_hd__decap_6
XFILLER_81_288 vssd1 vssd1 vccd1 vccd1 sky130_fd_sc_hd__decap_3
XTAP_TAPCELL_ROW_80_913 vssd1 vccd1 sky130_fd_sc_hd__tapvpwrvgnd_1
XFILLER_34_171 vssd1 vssd1 vccd1 vccd1 sky130_fd_sc_hd__decap_8
XTAP_TAPCELL_ROW_52_659 vssd1 vccd1 sky130_fd_sc_hd__tapvpwrvgnd_1
XANTENNA_fanout331_A _4332_/A vssd1 vssd1 vccd1 vccd1 sky130_fd_sc_hd__diode_2
XFILLER_22_377 vssd1 vssd1 vccd1 vccd1 sky130_fd_sc_hd__decap_6
XANTENNA__4014__A1 _4075_/S vssd1 vssd1 vccd1 vccd1 sky130_fd_sc_hd__diode_2
X_2959_ _4765_/Q _4780_/Q vssd1 vssd1 vccd1 vccd1 _2960_/B sky130_fd_sc_hd__nor2_1
XANTENNA__2328__A1 _4087_/S vssd1 vssd1 vccd1 vccd1 sky130_fd_sc_hd__diode_2
X_4629_ _4631_/CLK _4629_/D fanout410/X vssd1 vssd1 vccd1 vccd1 _4629_/Q sky130_fd_sc_hd__dfrtp_1
XFILLER_45_403 vssd1 vssd1 vccd1 vccd1 sky130_fd_sc_hd__fill_1
XFILLER_17_127 vssd1 vssd1 vccd1 vccd1 sky130_fd_sc_hd__fill_1
XFILLER_72_244 vssd1 vssd1 vccd1 vccd1 sky130_fd_sc_hd__decap_3
XFILLER_72_277 vccd1 vssd1 vccd1 vssd1 sky130_ef_sc_hd__decap_12
XFILLER_13_333 vssd1 vssd1 vccd1 vccd1 sky130_fd_sc_hd__decap_3
XTAP_TAPCELL_ROW_15_328 vssd1 vccd1 sky130_fd_sc_hd__tapvpwrvgnd_1
XFILLER_53_491 vssd1 vssd1 vccd1 vccd1 sky130_fd_sc_hd__decap_8
XANTENNA__3461__C1 _3923_/A vssd1 vssd1 vccd1 vccd1 sky130_fd_sc_hd__diode_2
XFILLER_9_337 vccd1 vssd1 vccd1 vssd1 sky130_ef_sc_hd__decap_12
XTAP_TAPCELL_ROW_23_394 vssd1 vccd1 sky130_fd_sc_hd__tapvpwrvgnd_1
Xoutput60 hold66/A vssd1 vssd1 vccd1 vccd1 m_axis_tdata[30] sky130_fd_sc_hd__buf_2
Xoutput71 hold23/A vssd1 vssd1 vccd1 vccd1 m_axis_tdata[4] sky130_fd_sc_hd__buf_2
XFILLER_0_281 vssd1 vssd1 vccd1 vccd1 sky130_fd_sc_hd__fill_2
XANTENNA__3989__C _4001_/C vssd1 vssd1 vccd1 vccd1 sky130_fd_sc_hd__diode_2
XFILLER_48_274 vccd1 vssd1 vccd1 vssd1 sky130_ef_sc_hd__decap_12
X_3931_ _2274_/B _3943_/A2 _3929_/X _3930_/X vssd1 vssd1 vccd1 vccd1 _4670_/D sky130_fd_sc_hd__a31o_1
X_3862_ _3862_/A _3862_/B _3862_/C _3862_/D vssd1 vssd1 vccd1 vccd1 _3864_/A sky130_fd_sc_hd__nand4_1
XFILLER_31_185 vssd1 vssd1 vccd1 vccd1 sky130_fd_sc_hd__fill_2
X_2813_ _2812_/A _2812_/B _2812_/C vssd1 vssd1 vccd1 vccd1 _2814_/B sky130_fd_sc_hd__o21a_1
XFILLER_31_196 vccd1 vssd1 vccd1 vssd1 sky130_ef_sc_hd__decap_12
X_3793_ _4581_/Q _3162_/B _2369_/S _3549_/A vssd1 vssd1 vccd1 vccd1 _4614_/D sky130_fd_sc_hd__a31o_1
X_2744_ _2740_/X _2742_/Y _4728_/Q vssd1 vssd1 vccd1 vccd1 _2745_/B sky130_fd_sc_hd__o21bai_2
X_2675_ _2690_/A _2690_/B _2690_/C vssd1 vssd1 vccd1 vccd1 _2675_/Y sky130_fd_sc_hd__a21oi_1
X_4414_ _4549_/CLK _4414_/D fanout415/X vssd1 vssd1 vccd1 vccd1 hold71/A sky130_fd_sc_hd__dfrtp_1
Xfanout305 _4800_/Q vssd1 vssd1 vccd1 vccd1 _4364_/A sky130_fd_sc_hd__buf_2
XANTENNA__4180__B1 _4361_/B1 vssd1 vssd1 vccd1 vccd1 sky130_fd_sc_hd__diode_2
X_4345_ _4344_/A _4328_/C _4328_/B _4314_/S _4344_/Y vssd1 vssd1 vccd1 vccd1 _4345_/X
+ sky130_fd_sc_hd__a311o_1
Xfanout327 _2304_/A1 vssd1 vssd1 vccd1 vccd1 _4063_/S sky130_fd_sc_hd__clkbuf_4
Xfanout338 _4253_/S vssd1 vssd1 vccd1 vccd1 _4119_/S sky130_fd_sc_hd__buf_2
XPHY_EDGE_ROW_21_Left_109 vssd1 vssd1 vccd1 vccd1 sky130_fd_sc_hd__decap_3
Xfanout316 _3950_/A2 vssd1 vssd1 vccd1 vccd1 _4075_/S sky130_fd_sc_hd__buf_2
XFILLER_86_347 vccd1 vssd1 vccd1 vssd1 sky130_ef_sc_hd__decap_12
Xfanout349 _3023_/A vssd1 vssd1 vccd1 vccd1 _3049_/B sky130_fd_sc_hd__buf_2
X_4276_ _4275_/Y _4274_/X _4273_/X hold164/X _4280_/B2 vssd1 vssd1 vccd1 vccd1 _4761_/D
+ sky130_fd_sc_hd__o32a_1
XANTENNA_fanout281_A _4104_/B vssd1 vssd1 vccd1 vccd1 sky130_fd_sc_hd__diode_2
XANTENNA_fanout379_A fanout405/X vssd1 vssd1 vccd1 vccd1 sky130_fd_sc_hd__diode_2
X_3227_ _3286_/A vssd1 vssd1 vccd1 vccd1 _3227_/Y sky130_fd_sc_hd__inv_2
X_3158_ _3158_/A _3158_/B vssd1 vssd1 vccd1 vccd1 _3158_/Y sky130_fd_sc_hd__nand2_1
XANTENNA__4076__B _4810_/Q vssd1 vssd1 vccd1 vccd1 sky130_fd_sc_hd__diode_2
X_3089_ _3089_/A _3089_/B _3089_/C vssd1 vssd1 vccd1 vccd1 _3091_/A sky130_fd_sc_hd__and3_1
XTAP_TAPCELL_ROW_65_773 vssd1 vccd1 sky130_fd_sc_hd__tapvpwrvgnd_1
XANTENNA_fanout334_X _4123_/S vssd1 vssd1 vccd1 vccd1 sky130_fd_sc_hd__diode_2
XPHY_EDGE_ROW_30_Left_118 vssd1 vssd1 vccd1 vccd1 sky130_fd_sc_hd__decap_3
XANTENNA__2340__A _4037_/C vssd1 vssd1 vccd1 vccd1 sky130_fd_sc_hd__diode_2
XANTENNA__4171__A0 _4171_/A0 vssd1 vssd1 vccd1 vccd1 sky130_fd_sc_hd__diode_2
XFILLER_77_347 vssd1 vssd1 vccd1 vccd1 sky130_fd_sc_hd__fill_1
XFILLER_18_403 vssd1 vssd1 vccd1 vccd1 sky130_fd_sc_hd__decap_6
XTAP_TAPCELL_ROW_28_442 vssd1 vccd1 sky130_fd_sc_hd__tapvpwrvgnd_1
XANTENNA__3434__C1 _3923_/A vssd1 vssd1 vccd1 vccd1 sky130_fd_sc_hd__diode_2
XANTENNA__4206__S _4273_/S vssd1 vssd1 vccd1 vccd1 sky130_fd_sc_hd__diode_2
XANTENNA__4152__D _4219_/C vssd1 vssd1 vccd1 vccd1 sky130_fd_sc_hd__diode_2
X_2460_ _2453_/Y _2459_/Y _3806_/A2 vssd1 vssd1 vccd1 vccd1 _2460_/Y sky130_fd_sc_hd__o21ai_1
X_4130_ _4127_/X _4128_/X _4129_/Y _4130_/B1 hold90/X vssd1 vssd1 vccd1 vccd1 _4724_/D
+ sky130_fd_sc_hd__o32a_1
X_2391_ _4563_/Q hold81/A _2425_/S vssd1 vssd1 vccd1 vccd1 _2391_/X sky130_fd_sc_hd__mux2_1
X_4061_ _4123_/S _4081_/A2 _4122_/B1 vssd1 vssd1 vccd1 vccd1 _4061_/Y sky130_fd_sc_hd__o21ai_1
XTAP_TAPCELL_ROW_79_898 vssd1 vccd1 sky130_fd_sc_hd__tapvpwrvgnd_1
X_3012_ _3028_/A _3010_/X _2960_/Y _2969_/A vssd1 vssd1 vccd1 vccd1 _3013_/B sky130_fd_sc_hd__a211o_1
XTAP_TAPCELL_ROW_62_743 vssd1 vccd1 sky130_fd_sc_hd__tapvpwrvgnd_1
X_3914_ _2274_/A _3946_/A1 hold148/X vssd1 vssd1 vccd1 vccd1 _3914_/Y sky130_fd_sc_hd__a21oi_1
X_3845_ _3029_/Y _3041_/Y _3042_/Y vssd1 vssd1 vccd1 vccd1 _3845_/Y sky130_fd_sc_hd__a21oi_1
X_3776_ _4535_/Q _4644_/Q _4536_/Q _4645_/Q vssd1 vssd1 vccd1 vccd1 _3776_/X sky130_fd_sc_hd__a22o_1
XANTENNA_fanout127_A _4314_/S vssd1 vssd1 vccd1 vccd1 sky130_fd_sc_hd__diode_2
X_2727_ _2725_/A _2726_/Y _4523_/Q _3870_/B1 vssd1 vssd1 vccd1 vccd1 _4523_/D sky130_fd_sc_hd__o2bb2a_1
X_2658_ _4657_/Q _4756_/Q vssd1 vssd1 vccd1 vccd1 _2716_/A sky130_fd_sc_hd__nand2_1
Xfanout113 _2428_/Y vssd1 vssd1 vccd1 vccd1 _3869_/S sky130_fd_sc_hd__dlymetal6s2s_1
X_2589_ _2621_/B _2589_/B vssd1 vssd1 vccd1 vccd1 _2590_/B sky130_fd_sc_hd__nor2_1
Xfanout102 _3425_/A2 vssd1 vssd1 vccd1 vccd1 _3396_/A2 sky130_fd_sc_hd__buf_2
Xfanout124 _3975_/S vssd1 vssd1 vccd1 vccd1 _3928_/S sky130_fd_sc_hd__clkbuf_4
Xfanout135 _3922_/B1 vssd1 vssd1 vccd1 vccd1 _2321_/B2 sky130_fd_sc_hd__buf_1
Xfanout146 _2273_/X vssd1 vssd1 vccd1 vccd1 _3922_/B1 sky130_fd_sc_hd__clkbuf_2
X_4328_ _4328_/A _4328_/B _4328_/C vssd1 vssd1 vccd1 vccd1 _4328_/X sky130_fd_sc_hd__and3_1
Xfanout179 _3893_/X vssd1 vssd1 vccd1 vccd1 _4305_/A0 sky130_fd_sc_hd__dlymetal6s2s_1
Xfanout157 _4369_/B1 vssd1 vssd1 vccd1 vccd1 _4358_/A2 sky130_fd_sc_hd__buf_2
Xfanout168 _4171_/A1 vssd1 vssd1 vccd1 vccd1 _4167_/A1 sky130_fd_sc_hd__buf_2
XANTENNA_fanout284_X _4064_/C vssd1 vssd1 vccd1 vccd1 sky130_fd_sc_hd__diode_2
XANTENNA_input1_A m_axis_tready vssd1 vssd1 vccd1 vccd1 sky130_fd_sc_hd__diode_2
X_4259_ _4324_/A _4279_/A2 _4264_/B2 vssd1 vssd1 vccd1 vccd1 _4259_/Y sky130_fd_sc_hd__o21ai_1
XFILLER_74_339 vssd1 vssd1 vccd1 vccd1 sky130_fd_sc_hd__decap_8
XANTENNA__4208__A1 _4340_/A vssd1 vssd1 vccd1 vccd1 sky130_fd_sc_hd__diode_2
XTAP_TAPCELL_ROW_25_412 vssd1 vccd1 sky130_fd_sc_hd__tapvpwrvgnd_1
XANTENNA__4392__A0 _4368_/A vssd1 vssd1 vccd1 vccd1 sky130_fd_sc_hd__diode_2
XFILLER_10_199 vssd1 vssd1 vccd1 vccd1 sky130_fd_sc_hd__decap_8
XFILLER_2_365 vccd1 vssd1 vccd1 vssd1 sky130_ef_sc_hd__decap_12
XANTENNA__3613__B _3613_/B vssd1 vssd1 vccd1 vccd1 sky130_fd_sc_hd__diode_2
XANTENNA_clkbuf_leaf_8_clk_A clkload1/A vssd1 vssd1 vccd1 vccd1 sky130_fd_sc_hd__diode_2
XFILLER_80_309 vssd1 vssd1 vccd1 vccd1 sky130_fd_sc_hd__fill_2
XFILLER_18_244 vssd1 vssd1 vccd1 vccd1 sky130_fd_sc_hd__fill_1
XFILLER_14_483 vssd1 vssd1 vccd1 vccd1 sky130_fd_sc_hd__decap_6
X_3630_ _3609_/Y _3628_/Y _3657_/C vssd1 vssd1 vccd1 vccd1 _3630_/Y sky130_fd_sc_hd__a21boi_1
X_3561_ _3561_/A _3613_/B _3561_/C vssd1 vssd1 vccd1 vccd1 _3561_/X sky130_fd_sc_hd__and3_1
XANTENNA__4383__A0 _4064_/D vssd1 vssd1 vccd1 vccd1 sky130_fd_sc_hd__diode_2
X_2512_ _4721_/Q _4706_/Q vssd1 vssd1 vccd1 vccd1 _2522_/B sky130_fd_sc_hd__nor2_1
XFILLER_52_3 vssd1 vssd1 vccd1 vccd1 sky130_fd_sc_hd__decap_8
X_3492_ _3491_/A _3491_/C _3491_/B vssd1 vssd1 vccd1 vccd1 _3492_/X sky130_fd_sc_hd__a21o_1
XANTENNA__4135__A0 _4171_/A0 vssd1 vssd1 vccd1 vccd1 sky130_fd_sc_hd__diode_2
X_2443_ _4686_/Q _4673_/Q vssd1 vssd1 vccd1 vccd1 _2445_/A sky130_fd_sc_hd__and2_1
X_2374_ hold9/X _2373_/X _2382_/S vssd1 vssd1 vccd1 vccd1 _4482_/D sky130_fd_sc_hd__mux2_1
X_4113_ _4116_/B _4171_/A1 _3886_/S vssd1 vssd1 vccd1 vccd1 _4113_/X sky130_fd_sc_hd__a21o_1
X_4044_ _4120_/C _4044_/B _4044_/C vssd1 vssd1 vccd1 vccd1 _4044_/X sky130_fd_sc_hd__and3b_1
XTAP_TAPCELL_ROW_39_537 vssd1 vccd1 sky130_fd_sc_hd__tapvpwrvgnd_1
XFILLER_24_203 vssd1 vssd1 vccd1 vccd1 sky130_fd_sc_hd__fill_1
XFILLER_20_475 vssd1 vssd1 vccd1 vccd1 sky130_fd_sc_hd__fill_1
XANTENNA_fanout411_A fanout414/X vssd1 vssd1 vccd1 vccd1 sky130_fd_sc_hd__diode_2
X_3828_ hold194/X _3828_/A2 _3827_/Y vssd1 vssd1 vccd1 vccd1 _4632_/D sky130_fd_sc_hd__a21o_1
X_3759_ _3759_/A _3759_/B _3759_/C _3759_/D vssd1 vssd1 vccd1 vccd1 _3759_/X sky130_fd_sc_hd__or4_1
XFILLER_47_306 vssd1 vssd1 vccd1 vccd1 sky130_fd_sc_hd__fill_1
XTAP_TAPCELL_ROW_73_849 vssd1 vccd1 sky130_fd_sc_hd__tapvpwrvgnd_1
XFILLER_7_446 vssd1 vssd1 vccd1 vccd1 sky130_fd_sc_hd__fill_2
XFILLER_2_195 vssd1 vssd1 vccd1 vccd1 sky130_fd_sc_hd__fill_1
XFILLER_38_328 vssd1 vssd1 vccd1 vccd1 sky130_fd_sc_hd__decap_3
XFILLER_17_6 vssd1 vssd1 vccd1 vccd1 sky130_fd_sc_hd__fill_1
XFILLER_65_158 vssd1 vssd1 vccd1 vccd1 sky130_fd_sc_hd__decap_3
XANTENNA__3997__C _4001_/C vssd1 vssd1 vccd1 vccd1 sky130_fd_sc_hd__diode_2
XFILLER_46_361 vssd1 vssd1 vccd1 vccd1 sky130_fd_sc_hd__fill_1
X_4800_ _4815_/CLK _4800_/D fanout395/X vssd1 vssd1 vccd1 vccd1 _4800_/Q sky130_fd_sc_hd__dfrtp_2
X_2992_ _3049_/B _4751_/Q vssd1 vssd1 vccd1 vccd1 _2993_/A sky130_fd_sc_hd__nor2_1
XTAP_TAPCELL_ROW_44_584 vssd1 vccd1 sky130_fd_sc_hd__tapvpwrvgnd_1
X_4731_ _4771_/CLK _4731_/D fanout392/X vssd1 vssd1 vccd1 vccd1 hold78/A sky130_fd_sc_hd__dfrtp_1
X_4662_ _4808_/CLK _4662_/D fanout378/X vssd1 vssd1 vccd1 vccd1 _4662_/Q sky130_fd_sc_hd__dfrtp_1
X_3613_ _3613_/A _3613_/B _3613_/C vssd1 vssd1 vccd1 vccd1 _3613_/X sky130_fd_sc_hd__and3_1
X_4593_ _4593_/CLK _4593_/D fanout413/X vssd1 vssd1 vccd1 vccd1 _4593_/Q sky130_fd_sc_hd__dfrtp_2
X_3544_ _4509_/Q _4616_/Q vssd1 vssd1 vccd1 vccd1 _3544_/Y sky130_fd_sc_hd__nand2_1
XANTENNA__4108__B1 _4361_/B1 vssd1 vssd1 vccd1 vccd1 sky130_fd_sc_hd__diode_2
X_3475_ _3475_/A _3475_/B _3474_/B vssd1 vssd1 vccd1 vccd1 _3475_/X sky130_fd_sc_hd__or3b_1
X_2426_ hold91/X _2425_/X _2426_/S vssd1 vssd1 vccd1 vccd1 _4508_/D sky130_fd_sc_hd__mux2_1
XFILLER_69_431 vccd1 vssd1 vccd1 vssd1 sky130_ef_sc_hd__decap_12
X_2357_ _4546_/Q hold29/A _2365_/S vssd1 vssd1 vccd1 vccd1 _2357_/X sky130_fd_sc_hd__mux2_1
XANTENNA__4068__C _4100_/C vssd1 vssd1 vccd1 vccd1 sky130_fd_sc_hd__diode_2
XFILLER_84_456 vccd1 vssd1 vccd1 vssd1 sky130_ef_sc_hd__decap_12
X_2288_ _4120_/D _2295_/C _2295_/B _3900_/B _2287_/Y vssd1 vssd1 vccd1 vccd1 _2288_/X
+ sky130_fd_sc_hd__a311o_1
XFILLER_84_489 vccd1 vssd1 vccd1 vssd1 sky130_ef_sc_hd__decap_12
XANTENNA_fanout361_A _3794_/A0 vssd1 vssd1 vccd1 vccd1 sky130_fd_sc_hd__diode_2
X_4027_ _4026_/Y _4025_/X _4024_/X _4698_/Q _4039_/B2 vssd1 vssd1 vccd1 vccd1 _4698_/D
+ sky130_fd_sc_hd__o32a_1
XFILLER_44_309 vccd1 vssd1 vccd1 vssd1 sky130_ef_sc_hd__decap_12
XTAP_TAPCELL_ROW_70_819 vssd1 vccd1 sky130_fd_sc_hd__tapvpwrvgnd_1
XANTENNA__4084__B _4104_/B vssd1 vssd1 vccd1 vccd1 sky130_fd_sc_hd__diode_2
XANTENNA_fanout247_X _2419_/S vssd1 vssd1 vccd1 vccd1 sky130_fd_sc_hd__diode_2
XFILLER_12_239 vccd1 vssd1 vccd1 vssd1 sky130_ef_sc_hd__decap_12
XANTENNA_fanout414_X fanout414/X vssd1 vssd1 vccd1 vccd1 sky130_fd_sc_hd__diode_2
XANTENNA__4250__D _4313_/S vssd1 vssd1 vccd1 vccd1 sky130_fd_sc_hd__diode_2
XFILLER_4_449 vccd1 vssd1 vccd1 vssd1 sky130_ef_sc_hd__decap_12
XFILLER_69_68 vssd1 vssd1 vccd1 vccd1 sky130_fd_sc_hd__fill_1
XTAP_TAPCELL_ROW_7_254 vssd1 vccd1 sky130_fd_sc_hd__tapvpwrvgnd_1
XFILLER_75_434 vssd1 vssd1 vccd1 vccd1 sky130_fd_sc_hd__decap_4
XTAP_TAPCELL_ROW_86_963 vssd1 vccd1 sky130_fd_sc_hd__tapvpwrvgnd_1
XFILLER_47_169 vssd1 vssd1 vccd1 vccd1 sky130_fd_sc_hd__fill_1
XFILLER_18_83 vssd1 vssd1 vccd1 vccd1 sky130_fd_sc_hd__fill_1
XANTENNA__4725__RESET_B fanout382/X vssd1 vssd1 vccd1 vccd1 sky130_fd_sc_hd__diode_2
XANTENNA__3389__A1 _3423_/A1 vssd1 vssd1 vccd1 vccd1 sky130_fd_sc_hd__diode_2
XFILLER_34_82 vssd1 vssd1 vccd1 vccd1 sky130_fd_sc_hd__fill_2
XFILLER_34_93 vssd1 vssd1 vccd1 vccd1 sky130_fd_sc_hd__fill_1
XTAP_TAPCELL_ROW_41_554 vssd1 vccd1 sky130_fd_sc_hd__tapvpwrvgnd_1
XANTENNA__4214__S _4219_/C vssd1 vssd1 vccd1 vccd1 sky130_fd_sc_hd__diode_2
XFILLER_7_221 vssd1 vssd1 vccd1 vccd1 sky130_fd_sc_hd__fill_1
XANTENNA__4160__D _4227_/C vssd1 vssd1 vccd1 vccd1 sky130_fd_sc_hd__diode_2
X_3260_ _4543_/Q _4584_/Q vssd1 vssd1 vccd1 vccd1 _3266_/C sky130_fd_sc_hd__or2_2
X_3191_ _3191_/A _3191_/B _3191_/C vssd1 vssd1 vccd1 vccd1 _3302_/C sky130_fd_sc_hd__nor3_1
X_2211_ _4513_/Q vssd1 vssd1 vccd1 vccd1 _3578_/A sky130_fd_sc_hd__inv_2
XFILLER_78_294 vssd1 vssd1 vccd1 vccd1 sky130_fd_sc_hd__fill_2
XFILLER_15_3 vssd1 vssd1 vccd1 vccd1 sky130_fd_sc_hd__decap_4
XTAP_TAPCELL_ROW_49_632 vssd1 vccd1 sky130_fd_sc_hd__tapvpwrvgnd_1
XFILLER_26_309 vssd1 vssd1 vccd1 vccd1 sky130_fd_sc_hd__decap_3
X_2975_ _2975_/A _2975_/B vssd1 vssd1 vccd1 vccd1 _2977_/C sky130_fd_sc_hd__nand2_1
XANTENNA__4041__A2 _3976_/D vssd1 vssd1 vccd1 vccd1 sky130_fd_sc_hd__diode_2
X_4714_ _4744_/CLK _4714_/D fanout391/X vssd1 vssd1 vccd1 vccd1 _4714_/Q sky130_fd_sc_hd__dfrtp_1
X_4645_ _4647_/CLK _4645_/D fanout430/X vssd1 vssd1 vccd1 vccd1 _4645_/Q sky130_fd_sc_hd__dfrtp_4
XANTENNA__4329__B1 _4338_/A2 vssd1 vssd1 vccd1 vccd1 sky130_fd_sc_hd__diode_2
X_4576_ _4576_/CLK _4576_/D fanout438/X vssd1 vssd1 vccd1 vccd1 _4576_/Q sky130_fd_sc_hd__dfrtp_1
X_3527_ _3528_/B _3528_/A vssd1 vssd1 vccd1 vccd1 _3531_/C sky130_fd_sc_hd__nand2_1
XANTENNA_clkbuf_leaf_33_clk_A clkload2/A vssd1 vssd1 vccd1 vccd1 sky130_fd_sc_hd__diode_2
X_3458_ _3458_/A _3458_/B vssd1 vssd1 vccd1 vccd1 _3458_/Y sky130_fd_sc_hd__nand2_1
X_2409_ _4572_/Q hold77/A _2421_/S vssd1 vssd1 vccd1 vccd1 _2409_/X sky130_fd_sc_hd__mux2_1
XFILLER_76_209 vccd1 vssd1 vccd1 vssd1 sky130_ef_sc_hd__decap_12
XTAP_TAPCELL_ROW_4_224 vssd1 vccd1 sky130_fd_sc_hd__tapvpwrvgnd_1
XANTENNA_fanout197_X _2366_/S vssd1 vssd1 vccd1 vccd1 sky130_fd_sc_hd__diode_2
X_3389_ _3423_/A1 _3387_/Y _3388_/X _3423_/B1 vssd1 vssd1 vccd1 vccd1 _3389_/X sky130_fd_sc_hd__a31o_1
XFILLER_84_253 vssd1 vssd1 vccd1 vccd1 sky130_fd_sc_hd__fill_1
XFILLER_29_169 vssd1 vssd1 vccd1 vccd1 sky130_fd_sc_hd__decap_4
XTAP_TAPCELL_ROW_83_933 vssd1 vccd1 sky130_fd_sc_hd__tapvpwrvgnd_1
XANTENNA_clkbuf_leaf_48_clk_A clkload0/A vssd1 vssd1 vccd1 vccd1 sky130_fd_sc_hd__diode_2
XANTENNA_fanout364_X _3541_/B1 vssd1 vssd1 vccd1 vccd1 sky130_fd_sc_hd__diode_2
XFILLER_80_481 vssd1 vssd1 vccd1 vccd1 sky130_fd_sc_hd__fill_1
XFILLER_71_69 vssd1 vssd1 vccd1 vccd1 sky130_fd_sc_hd__fill_2
XFILLER_20_62 vssd1 vssd1 vccd1 vccd1 sky130_fd_sc_hd__decap_6
XFILLER_20_95 vssd1 vssd1 vccd1 vccd1 sky130_fd_sc_hd__decap_8
XFILLER_29_60 vssd1 vssd1 vccd1 vccd1 sky130_fd_sc_hd__fill_2
Xhold60 hold60/A vssd1 vssd1 vccd1 vccd1 hold60/X sky130_fd_sc_hd__dlygate4sd3_1
Xhold71 hold71/A vssd1 vssd1 vccd1 vccd1 hold71/X sky130_fd_sc_hd__dlygate4sd3_1
Xhold82 hold82/A vssd1 vssd1 vccd1 vccd1 hold82/X sky130_fd_sc_hd__dlygate4sd3_1
XFILLER_48_456 vssd1 vssd1 vccd1 vccd1 sky130_fd_sc_hd__decap_6
XTAP_TAPCELL_ROW_46_602 vssd1 vccd1 sky130_fd_sc_hd__tapvpwrvgnd_1
Xhold93 hold93/A vssd1 vssd1 vccd1 vccd1 hold93/X sky130_fd_sc_hd__dlygate4sd3_1
XTAP_TAPCELL_ROW_18_348 vssd1 vccd1 sky130_fd_sc_hd__tapvpwrvgnd_1
XFILLER_31_301 vccd1 vssd1 vccd1 vssd1 sky130_ef_sc_hd__decap_12
XFILLER_31_367 vssd1 vssd1 vccd1 vccd1 sky130_fd_sc_hd__decap_4
X_2760_ _2760_/A _2760_/B vssd1 vssd1 vccd1 vccd1 _2760_/X sky130_fd_sc_hd__or2_1
X_2691_ _2675_/Y _2691_/B vssd1 vssd1 vccd1 vccd1 _3823_/B sky130_fd_sc_hd__and2b_1
X_4430_ _4562_/CLK _4430_/D _3923_/C vssd1 vssd1 vccd1 vccd1 hold53/A sky130_fd_sc_hd__dfrtp_1
X_4361_ _4360_/A _4371_/C _3896_/X _4361_/B1 _4360_/Y vssd1 vssd1 vccd1 vccd1 _4361_/X
+ sky130_fd_sc_hd__a311o_1
X_3312_ _3524_/B _3312_/B vssd1 vssd1 vccd1 vccd1 _3313_/D sky130_fd_sc_hd__and2_1
X_4292_ _4291_/Y _4290_/X _4289_/X hold208/X _4295_/B1 vssd1 vssd1 vccd1 vccd1 _4765_/D
+ sky130_fd_sc_hd__o32a_1
X_3243_ _4550_/Q _4591_/Q vssd1 vssd1 vccd1 vccd1 _3243_/Y sky130_fd_sc_hd__nor2_1
XFILLER_39_401 vssd1 vssd1 vccd1 vccd1 sky130_fd_sc_hd__fill_1
X_3174_ _3498_/B _3187_/C vssd1 vssd1 vccd1 vccd1 _3491_/B sky130_fd_sc_hd__nand2_1
XFILLER_66_253 vssd1 vssd1 vccd1 vccd1 sky130_fd_sc_hd__fill_2
XANTENNA__4119__S _4119_/S vssd1 vssd1 vccd1 vccd1 sky130_fd_sc_hd__diode_2
XFILLER_26_139 vssd1 vssd1 vccd1 vccd1 sky130_fd_sc_hd__fill_1
XFILLER_81_267 vssd1 vssd1 vccd1 vccd1 sky130_fd_sc_hd__fill_1
XFILLER_25_29 vssd1 vssd1 vccd1 vccd1 sky130_fd_sc_hd__decap_3
XFILLER_34_183 vssd1 vssd1 vccd1 vccd1 sky130_fd_sc_hd__decap_4
X_2958_ _4765_/Q _4780_/Q vssd1 vssd1 vccd1 vccd1 _3005_/B sky130_fd_sc_hd__and2_1
XANTENNA_fanout324_A _4794_/Q vssd1 vssd1 vccd1 vccd1 sky130_fd_sc_hd__diode_2
X_4628_ _4631_/CLK _4628_/D fanout410/X vssd1 vssd1 vccd1 vccd1 _4628_/Q sky130_fd_sc_hd__dfrtp_1
X_2889_ _2872_/A _2835_/Y _2838_/Y _2836_/C vssd1 vssd1 vccd1 vccd1 _2893_/B sky130_fd_sc_hd__o211ai_2
XANTENNA__2328__A2 _2323_/B vssd1 vssd1 vccd1 vccd1 sky130_fd_sc_hd__diode_2
X_4559_ _4562_/CLK _4559_/D _3923_/C vssd1 vssd1 vccd1 vccd1 _4559_/Q sky130_fd_sc_hd__dfrtp_1
XANTENNA__3828__A2 _3828_/A2 vssd1 vssd1 vccd1 vccd1 sky130_fd_sc_hd__diode_2
XANTENNA__2338__A _4037_/D vssd1 vssd1 vccd1 vccd1 sky130_fd_sc_hd__diode_2
XFILLER_45_426 vssd1 vssd1 vccd1 vccd1 sky130_fd_sc_hd__fill_1
XFILLER_9_349 vssd1 vssd1 vccd1 vccd1 sky130_fd_sc_hd__fill_2
XTAP_TAPCELL_ROW_23_395 vssd1 vccd1 sky130_fd_sc_hd__tapvpwrvgnd_1
XFILLER_40_197 vccd1 vssd1 vccd1 vssd1 sky130_ef_sc_hd__decap_12
Xoutput61 hold52/A vssd1 vssd1 vccd1 vccd1 m_axis_tdata[31] sky130_fd_sc_hd__buf_2
Xoutput50 hold30/A vssd1 vssd1 vccd1 vccd1 m_axis_tdata[21] sky130_fd_sc_hd__buf_2
Xoutput72 hold20/A vssd1 vssd1 vccd1 vccd1 m_axis_tdata[5] sky130_fd_sc_hd__buf_2
XANTENNA__3989__D _4119_/S vssd1 vssd1 vccd1 vccd1 sky130_fd_sc_hd__diode_2
XFILLER_36_426 vssd1 vssd1 vccd1 vccd1 sky130_fd_sc_hd__decap_8
XFILLER_48_286 vssd1 vssd1 vccd1 vccd1 sky130_fd_sc_hd__decap_4
XANTENNA__4740__RESET_B fanout382/X vssd1 vssd1 vccd1 vccd1 sky130_fd_sc_hd__diode_2
XANTENNA__4244__A2 _4361_/B1 vssd1 vssd1 vccd1 vccd1 sky130_fd_sc_hd__diode_2
XFILLER_63_289 vssd1 vssd1 vccd1 vccd1 sky130_fd_sc_hd__fill_1
X_3930_ _3981_/D _3900_/X _3975_/S _4670_/Q vssd1 vssd1 vccd1 vccd1 _3930_/X sky130_fd_sc_hd__a2bb2o_1
X_3861_ _4770_/Q _3130_/A _3151_/A _3860_/X vssd1 vssd1 vccd1 vccd1 _3866_/A sky130_fd_sc_hd__o31a_1
XFILLER_16_194 vssd1 vssd1 vccd1 vccd1 sky130_fd_sc_hd__fill_2
XFILLER_82_3 vccd1 vssd1 vccd1 vssd1 sky130_ef_sc_hd__decap_12
X_3792_ _3791_/Y _3792_/A2 _3784_/Y vssd1 vssd1 vccd1 vccd1 _4613_/D sky130_fd_sc_hd__a21oi_1
X_2812_ _2812_/A _2812_/B _2812_/C vssd1 vssd1 vccd1 vccd1 _2814_/A sky130_fd_sc_hd__nor3_1
X_2743_ _2742_/Y _4728_/Q _2743_/C vssd1 vssd1 vccd1 vccd1 _2745_/A sky130_fd_sc_hd__nand3b_2
X_2674_ _2674_/A _2674_/B vssd1 vssd1 vccd1 vccd1 _2690_/C sky130_fd_sc_hd__xnor2_1
X_4413_ _4549_/CLK _4413_/D fanout415/X vssd1 vssd1 vccd1 vccd1 hold36/A sky130_fd_sc_hd__dfrtp_1
XANTENNA__4180__A1 _4313_/S vssd1 vssd1 vccd1 vccd1 sky130_fd_sc_hd__diode_2
X_4344_ _4344_/A _4344_/B vssd1 vssd1 vccd1 vccd1 _4344_/Y sky130_fd_sc_hd__nor2_1
Xfanout317 _3950_/A2 vssd1 vssd1 vccd1 vccd1 _4215_/C sky130_fd_sc_hd__buf_2
Xfanout339 _4253_/S vssd1 vssd1 vccd1 vccd1 _3984_/S sky130_fd_sc_hd__dlymetal6s2s_1
Xfanout306 _4800_/Q vssd1 vssd1 vccd1 vccd1 _4029_/D sky130_fd_sc_hd__buf_2
Xfanout328 _2304_/A1 vssd1 vssd1 vccd1 vccd1 _4203_/C sky130_fd_sc_hd__clkbuf_4
X_4275_ _4274_/D _4279_/A2 _4280_/B2 vssd1 vssd1 vccd1 vccd1 _4275_/Y sky130_fd_sc_hd__o21ai_1
XFILLER_86_359 vssd1 vssd1 vccd1 vccd1 sky130_fd_sc_hd__decap_4
X_3226_ _3225_/B _3226_/B _3226_/C vssd1 vssd1 vccd1 vccd1 _3286_/A sky130_fd_sc_hd__nand3b_2
X_3157_ hold218/X _3157_/A2 _3146_/X _3156_/Y vssd1 vssd1 vccd1 vccd1 _4538_/D sky130_fd_sc_hd__o22a_1
XANTENNA__4076__C _4104_/C vssd1 vssd1 vccd1 vccd1 sky130_fd_sc_hd__diode_2
XFILLER_54_234 vssd1 vssd1 vccd1 vccd1 sky130_fd_sc_hd__decap_8
X_3088_ _3150_/A _3061_/B _3087_/B _3087_/C _3064_/B vssd1 vssd1 vccd1 vccd1 _3089_/C
+ sky130_fd_sc_hd__a221o_1
XTAP_TAPCELL_ROW_65_774 vssd1 vccd1 sky130_fd_sc_hd__tapvpwrvgnd_1
XFILLER_42_418 vssd1 vssd1 vccd1 vccd1 sky130_fd_sc_hd__fill_2
XANTENNA__3443__B1 _3460_/B1 vssd1 vssd1 vccd1 vccd1 sky130_fd_sc_hd__diode_2
XANTENNA__2797__A2 _2797_/A2 vssd1 vssd1 vccd1 vccd1 sky130_fd_sc_hd__diode_2
XANTENNA__4092__B _4104_/B vssd1 vssd1 vccd1 vccd1 sky130_fd_sc_hd__diode_2
XFILLER_52_27 vssd1 vssd1 vccd1 vccd1 sky130_fd_sc_hd__fill_1
XFILLER_52_38 vssd1 vssd1 vccd1 vccd1 sky130_fd_sc_hd__fill_1
XANTENNA_fanout327_X _4063_/S vssd1 vssd1 vccd1 vccd1 sky130_fd_sc_hd__diode_2
XTAP_TAPCELL_ROW_20_365 vssd1 vccd1 sky130_fd_sc_hd__tapvpwrvgnd_1
XANTENNA__4171__A1 _4171_/A1 vssd1 vssd1 vccd1 vccd1 sky130_fd_sc_hd__diode_2
XFILLER_77_57 vssd1 vssd1 vccd1 vccd1 sky130_fd_sc_hd__decap_3
XFILLER_45_212 vssd1 vssd1 vccd1 vccd1 sky130_fd_sc_hd__fill_1
XTAP_TAPCELL_ROW_28_443 vssd1 vccd1 sky130_fd_sc_hd__tapvpwrvgnd_1
XFILLER_45_267 vccd1 vssd1 vccd1 vssd1 sky130_ef_sc_hd__decap_12
XFILLER_9_179 vccd1 vssd1 vccd1 vssd1 sky130_ef_sc_hd__decap_12
XANTENNA__4222__S _4227_/C vssd1 vssd1 vccd1 vccd1 sky130_fd_sc_hd__diode_2
X_2390_ hold30/X _2389_/X _2426_/S vssd1 vssd1 vccd1 vccd1 _4490_/D sky130_fd_sc_hd__mux2_1
XFILLER_68_315 vssd1 vssd1 vccd1 vccd1 sky130_fd_sc_hd__decap_4
X_4060_ _4116_/D _4104_/B _4064_/C _4123_/S vssd1 vssd1 vccd1 vccd1 _4060_/X sky130_fd_sc_hd__and4b_1
XTAP_TAPCELL_ROW_79_899 vssd1 vccd1 sky130_fd_sc_hd__tapvpwrvgnd_1
X_3011_ _2960_/Y _2969_/A _3028_/A _3010_/X vssd1 vssd1 vccd1 vccd1 _3028_/B sky130_fd_sc_hd__o211ai_2
X_3913_ _4231_/D _4239_/B _4178_/D vssd1 vssd1 vccd1 vccd1 _3913_/X sky130_fd_sc_hd__or3b_1
XTAP_TAPCELL_ROW_62_744 vssd1 vccd1 sky130_fd_sc_hd__tapvpwrvgnd_1
XFILLER_51_248 vssd1 vssd1 vccd1 vccd1 sky130_fd_sc_hd__fill_2
X_3844_ hold127/X _3848_/A2 _3843_/Y vssd1 vssd1 vccd1 vccd1 _4640_/D sky130_fd_sc_hd__a21o_1
X_3775_ _3774_/Y _3792_/A2 _3771_/Y vssd1 vssd1 vccd1 vccd1 _4611_/D sky130_fd_sc_hd__a21oi_1
X_2726_ _3825_/A _3825_/B _3830_/A2 vssd1 vssd1 vccd1 vccd1 _2726_/Y sky130_fd_sc_hd__a21oi_1
X_2657_ _4657_/Q _4756_/Q vssd1 vssd1 vccd1 vccd1 _2657_/X sky130_fd_sc_hd__and2_1
XANTENNA__3971__S _4036_/S vssd1 vssd1 vccd1 vccd1 sky130_fd_sc_hd__diode_2
XANTENNA__4153__A1 _4219_/C vssd1 vssd1 vccd1 vccd1 sky130_fd_sc_hd__diode_2
X_2588_ _2588_/A _2588_/B _2588_/C _2588_/D vssd1 vssd1 vccd1 vccd1 _2589_/B sky130_fd_sc_hd__and4_1
Xfanout103 _3162_/Y vssd1 vssd1 vccd1 vccd1 _3425_/A2 sky130_fd_sc_hd__buf_2
XANTENNA__4211__A_N _4258_/C vssd1 vssd1 vccd1 vccd1 sky130_fd_sc_hd__diode_2
XANTENNA__4368__A _4368_/A vssd1 vssd1 vccd1 vccd1 sky130_fd_sc_hd__diode_2
Xfanout114 _2797_/A2 vssd1 vssd1 vccd1 vccd1 _3806_/A2 sky130_fd_sc_hd__clkbuf_2
Xfanout125 _3890_/S vssd1 vssd1 vccd1 vccd1 _3975_/S sky130_fd_sc_hd__buf_2
Xfanout136 fanout141/X vssd1 vssd1 vccd1 vccd1 _4192_/B1 sky130_fd_sc_hd__clkbuf_2
Xfanout147 _4208_/B1 vssd1 vssd1 vccd1 vccd1 _4205_/B2 sky130_fd_sc_hd__clkbuf_2
X_4327_ _4339_/A0 _4343_/A1 _4332_/A vssd1 vssd1 vccd1 vccd1 _4327_/X sky130_fd_sc_hd__mux2_1
Xfanout158 _4369_/B1 vssd1 vssd1 vccd1 vccd1 _4378_/B2 sky130_fd_sc_hd__clkbuf_2
Xfanout169 _4112_/Y vssd1 vssd1 vccd1 vccd1 _4171_/A1 sky130_fd_sc_hd__buf_2
X_4258_ _4286_/A_N _4282_/B _4258_/C _4324_/A vssd1 vssd1 vccd1 vccd1 _4258_/X sky130_fd_sc_hd__and4b_1
XFILLER_74_307 vssd1 vssd1 vccd1 vccd1 sky130_fd_sc_hd__fill_1
X_3209_ _4558_/Q _4599_/Q _4598_/Q _4557_/Q vssd1 vssd1 vccd1 vccd1 _3209_/X sky130_fd_sc_hd__a22o_1
X_4189_ _4188_/Y _4187_/X _4186_/X hold114/X _4192_/B1 vssd1 vssd1 vccd1 vccd1 _4739_/D
+ sky130_fd_sc_hd__o32a_1
XANTENNA__4208__A2 _4212_/A2 vssd1 vssd1 vccd1 vccd1 sky130_fd_sc_hd__diode_2
XTAP_TAPCELL_ROW_25_413 vssd1 vccd1 sky130_fd_sc_hd__tapvpwrvgnd_1
XTAP_TAPCELL_ROW_33_490 vssd1 vccd1 sky130_fd_sc_hd__tapvpwrvgnd_1
XANTENNA_fanout92_X _4408_/S vssd1 vssd1 vccd1 vccd1 sky130_fd_sc_hd__diode_2
XFILLER_2_377 vssd1 vssd1 vccd1 vccd1 sky130_fd_sc_hd__fill_1
Xhold190 _4633_/Q vssd1 vssd1 vccd1 vccd1 hold190/X sky130_fd_sc_hd__dlygate4sd3_1
XFILLER_77_167 vssd1 vssd1 vccd1 vccd1 sky130_fd_sc_hd__fill_1
XTAP_TAPCELL_ROW_76_869 vssd1 vccd1 sky130_fd_sc_hd__tapvpwrvgnd_1
XPHY_EDGE_ROW_16_Right_16 vssd1 vssd1 vccd1 vccd1 sky130_fd_sc_hd__decap_3
XFILLER_53_81 vccd1 vssd1 vccd1 vssd1 sky130_ef_sc_hd__decap_12
XFILLER_41_281 vccd1 vssd1 vccd1 vssd1 sky130_ef_sc_hd__decap_12
X_3560_ _4510_/Q _4618_/Q _4619_/Q _3558_/Y vssd1 vssd1 vccd1 vccd1 _3561_/A sky130_fd_sc_hd__o211ai_4
XPHY_EDGE_ROW_25_Right_25 vssd1 vssd1 vccd1 vccd1 sky130_fd_sc_hd__decap_3
X_2511_ _4721_/Q _4706_/Q vssd1 vssd1 vccd1 vccd1 _2522_/A sky130_fd_sc_hd__and2_1
X_3491_ _3491_/A _3491_/B _3491_/C vssd1 vssd1 vccd1 vccd1 _3491_/Y sky130_fd_sc_hd__nand3_1
XANTENNA__4135__A1 _4167_/A1 vssd1 vssd1 vccd1 vccd1 sky130_fd_sc_hd__diode_2
X_2442_ _4659_/Q _2439_/B _2438_/A vssd1 vssd1 vccd1 vccd1 _2442_/Y sky130_fd_sc_hd__a21oi_1
XFILLER_68_112 vssd1 vssd1 vccd1 vccd1 sky130_fd_sc_hd__decap_4
X_2373_ _4554_/Q hold6/A _2381_/S vssd1 vssd1 vccd1 vccd1 _2373_/X sky130_fd_sc_hd__mux2_1
X_4112_ _4172_/B _4168_/C _4111_/Y vssd1 vssd1 vccd1 vccd1 _4112_/Y sky130_fd_sc_hd__a21oi_1
XFILLER_68_189 vssd1 vssd1 vccd1 vccd1 sky130_fd_sc_hd__fill_1
X_4043_ _4116_/B _4044_/B _4044_/C _4120_/C vssd1 vssd1 vccd1 vccd1 _4043_/X sky130_fd_sc_hd__and4b_1
XPHY_EDGE_ROW_34_Right_34 vssd1 vssd1 vccd1 vccd1 sky130_fd_sc_hd__decap_3
XFILLER_37_510 vssd1 vssd1 vccd1 vccd1 sky130_fd_sc_hd__fill_1
XTAP_TAPCELL_ROW_39_538 vssd1 vccd1 sky130_fd_sc_hd__tapvpwrvgnd_1
XANTENNA__4127__S _4266_/D vssd1 vssd1 vccd1 vccd1 sky130_fd_sc_hd__diode_2
XANTENNA_fanout237_A _2250_/S vssd1 vssd1 vccd1 vccd1 sky130_fd_sc_hd__diode_2
XFILLER_20_421 vssd1 vssd1 vccd1 vccd1 sky130_fd_sc_hd__decap_8
X_3827_ _2749_/Y _2760_/X _2761_/Y vssd1 vssd1 vccd1 vccd1 _3827_/Y sky130_fd_sc_hd__a21oi_1
XPHY_EDGE_ROW_43_Right_43 vssd1 vssd1 vccd1 vccd1 sky130_fd_sc_hd__decap_3
X_3758_ _4609_/Q _3792_/A2 _3757_/Y vssd1 vssd1 vccd1 vccd1 _4609_/D sky130_fd_sc_hd__o21a_1
XTAP_TAPCELL_ROW_30_460 vssd1 vccd1 sky130_fd_sc_hd__tapvpwrvgnd_1
XANTENNA_fanout404_A fanout405/X vssd1 vssd1 vccd1 vccd1 sky130_fd_sc_hd__diode_2
X_2709_ _2709_/A _2709_/B vssd1 vssd1 vccd1 vccd1 _2710_/B sky130_fd_sc_hd__nor2_1
X_3689_ _3689_/A vssd1 vssd1 vccd1 vccd1 _3689_/Y sky130_fd_sc_hd__inv_2
XFILLER_87_421 vssd1 vssd1 vccd1 vccd1 sky130_fd_sc_hd__decap_8
XFILLER_58_37 vssd1 vssd1 vccd1 vccd1 sky130_fd_sc_hd__fill_1
XPHY_EDGE_ROW_52_Right_52 vssd1 vssd1 vccd1 vccd1 sky130_fd_sc_hd__decap_3
XFILLER_59_167 vssd1 vssd1 vccd1 vccd1 sky130_fd_sc_hd__fill_1
XFILLER_55_340 vssd1 vssd1 vccd1 vccd1 sky130_fd_sc_hd__decap_4
XFILLER_82_192 vssd1 vssd1 vccd1 vccd1 sky130_fd_sc_hd__decap_4
XPHY_EDGE_ROW_61_Right_61 vssd1 vssd1 vccd1 vccd1 sky130_fd_sc_hd__decap_3
XFILLER_23_281 vssd1 vssd1 vccd1 vccd1 sky130_fd_sc_hd__fill_1
XANTENNA__4365__A1 _4364_/A vssd1 vssd1 vccd1 vccd1 sky130_fd_sc_hd__diode_2
XFILLER_78_421 vssd1 vssd1 vccd1 vccd1 sky130_fd_sc_hd__decap_6
XPHY_EDGE_ROW_70_Right_70 vssd1 vssd1 vccd1 vccd1 sky130_fd_sc_hd__decap_3
XFILLER_2_141 vccd1 vssd1 vccd1 vssd1 sky130_ef_sc_hd__decap_12
XANTENNA__3997__D _4064_/D vssd1 vssd1 vccd1 vccd1 sky130_fd_sc_hd__diode_2
XFILLER_0_66 vssd1 vssd1 vccd1 vccd1 sky130_fd_sc_hd__fill_1
X_2991_ _3049_/B _4751_/Q vssd1 vssd1 vccd1 vccd1 _2991_/Y sky130_fd_sc_hd__nand2_1
XFILLER_61_387 vssd1 vssd1 vccd1 vccd1 sky130_fd_sc_hd__decap_4
XTAP_TAPCELL_ROW_44_585 vssd1 vccd1 sky130_fd_sc_hd__tapvpwrvgnd_1
X_4730_ _4748_/CLK _4730_/D fanout390/X vssd1 vssd1 vccd1 vccd1 _4730_/Q sky130_fd_sc_hd__dfrtp_1
X_4661_ _4794_/CLK _4661_/D fanout377/X vssd1 vssd1 vccd1 vccd1 _4661_/Q sky130_fd_sc_hd__dfrtp_1
X_3612_ _3607_/Y _3609_/Y _3604_/X _3605_/Y vssd1 vssd1 vccd1 vccd1 _3613_/A sky130_fd_sc_hd__a211o_1
X_4592_ _4593_/CLK _4592_/D fanout413/X vssd1 vssd1 vccd1 vccd1 _4592_/Q sky130_fd_sc_hd__dfrtp_2
X_3543_ _3543_/A _3543_/B vssd1 vssd1 vccd1 vccd1 _3543_/Y sky130_fd_sc_hd__nand2_1
XANTENNA__4410__S _4410_/S vssd1 vssd1 vccd1 vccd1 sky130_fd_sc_hd__diode_2
X_3474_ _3474_/A _3474_/B vssd1 vssd1 vccd1 vccd1 _3474_/X sky130_fd_sc_hd__or2_1
X_2425_ _4580_/Q hold83/A _2425_/S vssd1 vssd1 vccd1 vccd1 _2425_/X sky130_fd_sc_hd__mux2_1
XFILLER_69_443 vssd1 vssd1 vccd1 vccd1 sky130_fd_sc_hd__decap_4
XFILLER_84_402 vccd1 vssd1 vccd1 vssd1 sky130_ef_sc_hd__decap_12
X_2356_ hold23/X _2355_/X _2366_/S vssd1 vssd1 vccd1 vccd1 _4473_/D sky130_fd_sc_hd__mux2_1
XANTENNA__4068__D _4203_/C vssd1 vssd1 vccd1 vccd1 sky130_fd_sc_hd__diode_2
X_2287_ _4120_/D _2338_/B vssd1 vssd1 vccd1 vccd1 _2287_/Y sky130_fd_sc_hd__nor2_1
XFILLER_84_468 vssd1 vssd1 vccd1 vccd1 sky130_fd_sc_hd__decap_8
X_4026_ _4087_/S _4038_/A2 _4039_/B2 vssd1 vssd1 vccd1 vccd1 _4026_/Y sky130_fd_sc_hd__o21ai_1
XANTENNA_fanout354_A _4377_/B1 vssd1 vssd1 vccd1 vccd1 sky130_fd_sc_hd__diode_2
XANTENNA__4084__C _4100_/C vssd1 vssd1 vccd1 vccd1 sky130_fd_sc_hd__diode_2
XFILLER_52_365 vccd1 vssd1 vccd1 vssd1 sky130_ef_sc_hd__decap_12
XANTENNA_clkbuf_leaf_7_clk_A clkload1/A vssd1 vssd1 vccd1 vccd1 sky130_fd_sc_hd__diode_2
XFILLER_60_38 vssd1 vssd1 vccd1 vccd1 sky130_fd_sc_hd__fill_1
XTAP_TAPCELL_ROW_7_255 vssd1 vccd1 sky130_fd_sc_hd__tapvpwrvgnd_1
XFILLER_75_402 vssd1 vssd1 vccd1 vccd1 sky130_fd_sc_hd__decap_4
XFILLER_85_57 vccd1 vssd1 vccd1 vssd1 sky130_ef_sc_hd__decap_12
XTAP_TAPCELL_ROW_86_964 vssd1 vccd1 sky130_fd_sc_hd__tapvpwrvgnd_1
XFILLER_85_79 vssd1 vssd1 vccd1 vccd1 sky130_fd_sc_hd__decap_4
XFILLER_75_479 vssd1 vssd1 vccd1 vccd1 sky130_fd_sc_hd__decap_8
XFILLER_83_490 vccd1 vssd1 vccd1 vssd1 sky130_ef_sc_hd__decap_12
XFILLER_70_195 vssd1 vssd1 vccd1 vccd1 sky130_fd_sc_hd__fill_1
XTAP_TAPCELL_ROW_41_555 vssd1 vccd1 sky130_fd_sc_hd__tapvpwrvgnd_1
XANTENNA__4230__S _4368_/A vssd1 vssd1 vccd1 vccd1 sky130_fd_sc_hd__diode_2
XFILLER_3_461 vccd1 vssd1 vccd1 vssd1 sky130_ef_sc_hd__decap_12
X_2210_ _4621_/Q vssd1 vssd1 vccd1 vccd1 _3572_/B sky130_fd_sc_hd__inv_2
X_3190_ _3187_/A _3498_/B _3173_/X _3308_/B _4572_/Q vssd1 vssd1 vccd1 vccd1 _3191_/A
+ sky130_fd_sc_hd__a32o_1
XFILLER_38_115 vssd1 vssd1 vccd1 vccd1 sky130_fd_sc_hd__decap_4
XTAP_TAPCELL_ROW_49_633 vssd1 vccd1 sky130_fd_sc_hd__tapvpwrvgnd_1
XFILLER_81_449 vssd1 vssd1 vccd1 vccd1 sky130_fd_sc_hd__decap_3
XANTENNA__4405__S _4408_/S vssd1 vssd1 vccd1 vccd1 sky130_fd_sc_hd__diode_2
X_2974_ _4764_/Q _4779_/Q _2975_/A vssd1 vssd1 vccd1 vccd1 _2977_/B sky130_fd_sc_hd__a21o_1
XANTENNA__2273__X _2273_/X vssd1 vssd1 vccd1 vccd1 sky130_fd_sc_hd__diode_2
X_4713_ _4745_/CLK _4713_/D fanout389/X vssd1 vssd1 vccd1 vccd1 _4713_/Q sky130_fd_sc_hd__dfrtp_1
XANTENNA__4702__Q _4702_/Q vssd1 vssd1 vccd1 vccd1 sky130_fd_sc_hd__diode_2
XANTENNA__4329__A1 _4328_/A vssd1 vssd1 vccd1 vccd1 sky130_fd_sc_hd__diode_2
X_4644_ _4644_/CLK _4644_/D fanout430/X vssd1 vssd1 vccd1 vccd1 _4644_/Q sky130_fd_sc_hd__dfrtp_1
XANTENNA__4435__RESET_B fanout435/X vssd1 vssd1 vccd1 vccd1 sky130_fd_sc_hd__diode_2
X_4575_ _4575_/CLK _4575_/D fanout438/X vssd1 vssd1 vccd1 vccd1 _4575_/Q sky130_fd_sc_hd__dfrtp_1
X_3526_ _4576_/Q _3522_/A2 _3504_/Y _3525_/Y vssd1 vssd1 vccd1 vccd1 _4576_/D sky130_fd_sc_hd__o2bb2ai_1
XANTENNA_fanout102_A _3425_/A2 vssd1 vssd1 vccd1 vccd1 sky130_fd_sc_hd__diode_2
X_3457_ _3451_/Y _3203_/B _3197_/X _3195_/A vssd1 vssd1 vccd1 vccd1 _3458_/A sky130_fd_sc_hd__a31o_1
X_2408_ hold66/X _2407_/X _2420_/S vssd1 vssd1 vccd1 vccd1 _4499_/D sky130_fd_sc_hd__mux2_1
X_3388_ _3279_/B _3380_/A _3380_/B _3243_/Y _3242_/Y vssd1 vssd1 vccd1 vccd1 _3388_/X
+ sky130_fd_sc_hd__a311o_1
XTAP_TAPCELL_ROW_4_225 vssd1 vccd1 sky130_fd_sc_hd__tapvpwrvgnd_1
X_2339_ _4037_/D _2335_/C _2335_/B _3975_/S _2338_/Y vssd1 vssd1 vccd1 vccd1 _2339_/X
+ sky130_fd_sc_hd__a311o_1
XPHY_EDGE_ROW_2_Right_2 vssd1 vssd1 vccd1 vccd1 sky130_fd_sc_hd__decap_3
XFILLER_29_137 vssd1 vssd1 vccd1 vccd1 sky130_fd_sc_hd__fill_1
XTAP_TAPCELL_ROW_83_934 vssd1 vccd1 sky130_fd_sc_hd__tapvpwrvgnd_1
X_4009_ _4009_/A_N _4037_/B _4037_/C _4071_/S vssd1 vssd1 vccd1 vccd1 _4009_/X sky130_fd_sc_hd__and4b_1
XANTENNA__2608__B _4754_/Q vssd1 vssd1 vccd1 vccd1 sky130_fd_sc_hd__diode_2
XFILLER_13_505 vssd1 vssd1 vccd1 vccd1 sky130_fd_sc_hd__fill_1
XANTENNA__4315__S _4320_/A vssd1 vssd1 vccd1 vccd1 sky130_fd_sc_hd__diode_2
XFILLER_52_195 vssd1 vssd1 vccd1 vccd1 sky130_fd_sc_hd__fill_1
XFILLER_4_269 vssd1 vssd1 vccd1 vccd1 sky130_fd_sc_hd__fill_2
XFILLER_0_453 vccd1 vssd1 vccd1 vssd1 sky130_ef_sc_hd__decap_12
Xhold50 hold50/A vssd1 vssd1 vccd1 vccd1 hold50/X sky130_fd_sc_hd__dlygate4sd3_1
XANTENNA_input32_A s_axis_tdata[7] vssd1 vssd1 vccd1 vccd1 sky130_fd_sc_hd__diode_2
Xhold61 hold61/A vssd1 vssd1 vccd1 vccd1 hold61/X sky130_fd_sc_hd__dlygate4sd3_1
XFILLER_48_468 vssd1 vssd1 vccd1 vccd1 sky130_fd_sc_hd__decap_8
Xhold72 hold72/A vssd1 vssd1 vccd1 vccd1 hold72/X sky130_fd_sc_hd__dlygate4sd3_1
Xhold83 hold83/A vssd1 vssd1 vccd1 vccd1 hold83/X sky130_fd_sc_hd__dlygate4sd3_1
XFILLER_63_405 vccd1 vssd1 vccd1 vssd1 sky130_ef_sc_hd__decap_12
Xhold94 hold94/A vssd1 vssd1 vccd1 vccd1 hold94/X sky130_fd_sc_hd__dlygate4sd3_1
XTAP_TAPCELL_ROW_46_603 vssd1 vccd1 sky130_fd_sc_hd__tapvpwrvgnd_1
XFILLER_63_449 vccd1 vssd1 vccd1 vssd1 sky130_ef_sc_hd__decap_12
XTAP_TAPCELL_ROW_18_349 vssd1 vccd1 sky130_fd_sc_hd__tapvpwrvgnd_1
XFILLER_16_343 vssd1 vssd1 vccd1 vccd1 sky130_fd_sc_hd__fill_1
XFILLER_16_365 vccd1 vssd1 vccd1 vssd1 sky130_ef_sc_hd__decap_12
XFILLER_31_335 vssd1 vssd1 vccd1 vccd1 sky130_fd_sc_hd__fill_1
X_2690_ _2690_/A _2690_/B _2690_/C vssd1 vssd1 vccd1 vccd1 _2691_/B sky130_fd_sc_hd__nand3_1
X_4360_ _4360_/A _4372_/B vssd1 vssd1 vccd1 vccd1 _4360_/Y sky130_fd_sc_hd__nor2_1
XANTENNA__3534__A2 _3534_/A2 vssd1 vssd1 vccd1 vccd1 sky130_fd_sc_hd__diode_2
X_3311_ _4575_/Q _3311_/B vssd1 vssd1 vccd1 vccd1 _3312_/B sky130_fd_sc_hd__or2_1
X_4291_ _4356_/A _4307_/A2 _4295_/B1 vssd1 vssd1 vccd1 vccd1 _4291_/Y sky130_fd_sc_hd__o21ai_1
X_3242_ _3242_/A _3242_/B vssd1 vssd1 vccd1 vccd1 _3242_/Y sky130_fd_sc_hd__nand2_1
X_3173_ _4570_/Q _4611_/Q _4610_/Q _4569_/Q vssd1 vssd1 vccd1 vccd1 _3173_/X sky130_fd_sc_hd__a22o_1
XANTENNA__4247__B1 _4314_/S vssd1 vssd1 vccd1 vccd1 sky130_fd_sc_hd__diode_2
XFILLER_66_287 vssd1 vssd1 vccd1 vccd1 sky130_fd_sc_hd__fill_1
XANTENNA__2428__B _4666_/Q vssd1 vssd1 vccd1 vccd1 sky130_fd_sc_hd__diode_2
Xclkbuf_leaf_46_clk clkload0/A vssd1 vssd1 vccd1 vccd1 _4702_/CLK sky130_fd_sc_hd__clkbuf_8
XFILLER_25_19 vssd1 vssd1 vccd1 vccd1 sky130_fd_sc_hd__fill_2
XANTENNA__4135__S _4274_/D vssd1 vssd1 vccd1 vccd1 sky130_fd_sc_hd__diode_2
X_2957_ _2953_/A _2952_/A _2952_/B _2954_/A _2954_/B vssd1 vssd1 vccd1 vccd1 _2971_/A
+ sky130_fd_sc_hd__o32a_1
XANTENNA__3974__S _4036_/S vssd1 vssd1 vccd1 vccd1 sky130_fd_sc_hd__diode_2
XFILLER_41_29 vssd1 vssd1 vccd1 vccd1 sky130_fd_sc_hd__fill_1
XANTENNA_fanout317_A _3950_/A2 vssd1 vssd1 vccd1 vccd1 sky130_fd_sc_hd__diode_2
X_2888_ _2845_/B _2845_/A _2845_/C vssd1 vssd1 vccd1 vccd1 _2893_/A sky130_fd_sc_hd__o21bai_2
X_4627_ _4631_/CLK _4627_/D fanout410/X vssd1 vssd1 vccd1 vccd1 _4627_/Q sky130_fd_sc_hd__dfrtp_2
XANTENNA_fanout105_X _3522_/A2 vssd1 vssd1 vccd1 vccd1 sky130_fd_sc_hd__diode_2
X_4558_ _4668_/CLK _4558_/D fanout423/X vssd1 vssd1 vccd1 vccd1 _4558_/Q sky130_fd_sc_hd__dfrtp_4
X_3509_ _4572_/Q _3534_/A2 _3508_/Y _3503_/X vssd1 vssd1 vccd1 vccd1 _4572_/D sky130_fd_sc_hd__a22o_1
X_4489_ _4579_/CLK _4489_/D fanout432/X vssd1 vssd1 vccd1 vccd1 hold34/A sky130_fd_sc_hd__dfrtp_1
XFILLER_57_287 vccd1 vssd1 vccd1 vssd1 sky130_ef_sc_hd__decap_12
Xclkbuf_leaf_37_clk clkload2/A vssd1 vssd1 vccd1 vccd1 _4553_/CLK sky130_fd_sc_hd__clkbuf_8
XTAP_TAPCELL_ROW_51_650 vssd1 vccd1 sky130_fd_sc_hd__tapvpwrvgnd_1
XTAP_TAPCELL_ROW_23_396 vssd1 vccd1 sky130_fd_sc_hd__tapvpwrvgnd_1
Xoutput40 hold2/A vssd1 vssd1 vccd1 vccd1 m_axis_tdata[12] sky130_fd_sc_hd__buf_2
Xoutput51 hold33/A vssd1 vssd1 vccd1 vccd1 m_axis_tdata[22] sky130_fd_sc_hd__buf_2
Xoutput62 hold74/A vssd1 vssd1 vccd1 vccd1 m_axis_tdata[32] sky130_fd_sc_hd__buf_2
Xoutput73 hold76/A vssd1 vssd1 vccd1 vccd1 m_axis_tdata[6] sky130_fd_sc_hd__buf_2
XFILLER_0_261 vccd1 vssd1 vccd1 vssd1 sky130_ef_sc_hd__decap_12
XFILLER_48_232 vssd1 vssd1 vccd1 vccd1 sky130_fd_sc_hd__decap_6
XANTENNA__3985__A_N _3976_/D vssd1 vssd1 vccd1 vccd1 sky130_fd_sc_hd__diode_2
Xclkbuf_leaf_28_clk clkbuf_2_3__f_clk/X vssd1 vssd1 vccd1 vccd1 _4580_/CLK sky130_fd_sc_hd__clkbuf_8
XFILLER_63_279 vssd1 vssd1 vccd1 vccd1 sky130_fd_sc_hd__fill_1
X_3860_ _4786_/Q _2871_/C _2873_/A _3142_/B _3859_/X vssd1 vssd1 vccd1 vccd1 _3860_/X
+ sky130_fd_sc_hd__a311o_1
X_3791_ _3791_/A _3791_/B vssd1 vssd1 vccd1 vccd1 _3791_/Y sky130_fd_sc_hd__nand2_1
XANTENNA_clkbuf_leaf_32_clk_A clkbuf_2_3__f_clk/X vssd1 vssd1 vccd1 vccd1 sky130_fd_sc_hd__diode_2
X_2811_ _4730_/Q _2811_/B vssd1 vssd1 vccd1 vccd1 _2812_/C sky130_fd_sc_hd__xnor2_2
X_2742_ _4743_/Q _4713_/Q vssd1 vssd1 vccd1 vccd1 _2742_/Y sky130_fd_sc_hd__nor2_1
X_4412_ _4587_/CLK _4412_/D fanout415/X vssd1 vssd1 vccd1 vccd1 hold61/A sky130_fd_sc_hd__dfrtp_1
XANTENNA_clkbuf_leaf_47_clk_A clkload0/A vssd1 vssd1 vccd1 vccd1 sky130_fd_sc_hd__diode_2
X_2673_ _4726_/Q _2673_/B vssd1 vssd1 vccd1 vccd1 _2674_/B sky130_fd_sc_hd__xnor2_1
XANTENNA__4180__A2 _4210_/A1 vssd1 vssd1 vccd1 vccd1 sky130_fd_sc_hd__diode_2
X_4343_ _4374_/A0 _4343_/A1 _4348_/A vssd1 vssd1 vccd1 vccd1 _4343_/X sky130_fd_sc_hd__mux2_1
Xfanout318 _3950_/A2 vssd1 vssd1 vccd1 vccd1 _4348_/A sky130_fd_sc_hd__clkbuf_2
Xfanout307 _4799_/Q vssd1 vssd1 vccd1 vccd1 _4087_/S sky130_fd_sc_hd__buf_2
Xfanout329 _2304_/A1 vssd1 vssd1 vccd1 vccd1 _4336_/A sky130_fd_sc_hd__dlymetal6s2s_1
X_4274_ _4286_/A_N _4282_/B _4302_/C _4274_/D vssd1 vssd1 vccd1 vccd1 _4274_/X sky130_fd_sc_hd__and4b_1
XANTENNA__3542__B _3613_/B vssd1 vssd1 vccd1 vccd1 sky130_fd_sc_hd__diode_2
X_3225_ _3225_/A _3225_/B vssd1 vssd1 vccd1 vccd1 _3225_/X sky130_fd_sc_hd__or2_1
X_3156_ _3147_/X _3155_/X _3156_/B1 vssd1 vssd1 vccd1 vccd1 _3156_/Y sky130_fd_sc_hd__o21ai_1
XFILLER_27_405 vssd1 vssd1 vccd1 vccd1 sky130_fd_sc_hd__decap_6
XFILLER_27_416 vccd1 vssd1 vccd1 vssd1 sky130_ef_sc_hd__decap_12
X_3087_ _3087_/A _3087_/B _3087_/C vssd1 vssd1 vccd1 vccd1 _3089_/B sky130_fd_sc_hd__nand3_1
XFILLER_27_449 vssd1 vssd1 vccd1 vccd1 sky130_fd_sc_hd__decap_8
XANTENNA__4076__D _4273_/S vssd1 vssd1 vccd1 vccd1 sky130_fd_sc_hd__diode_2
Xclkbuf_leaf_19_clk clkbuf_2_3__f_clk/X vssd1 vssd1 vccd1 vccd1 _4640_/CLK sky130_fd_sc_hd__clkbuf_8
XTAP_TAPCELL_ROW_65_775 vssd1 vccd1 sky130_fd_sc_hd__tapvpwrvgnd_1
XANTENNA_fanout267_A _4813_/Q vssd1 vssd1 vccd1 vccd1 sky130_fd_sc_hd__diode_2
XANTENNA__3443__A1 _3460_/A1 vssd1 vssd1 vccd1 vccd1 sky130_fd_sc_hd__diode_2
XANTENNA__3994__A2 _4022_/A2 vssd1 vssd1 vccd1 vccd1 sky130_fd_sc_hd__diode_2
XANTENNA_fanout434_A fanout435/X vssd1 vssd1 vccd1 vccd1 sky130_fd_sc_hd__diode_2
XFILLER_50_430 vssd1 vssd1 vccd1 vccd1 sky130_fd_sc_hd__fill_1
XANTENNA__4092__C _4100_/C vssd1 vssd1 vccd1 vccd1 sky130_fd_sc_hd__diode_2
X_3989_ _4064_/C _4001_/B _4001_/C _4119_/S vssd1 vssd1 vccd1 vccd1 _3989_/X sky130_fd_sc_hd__and4b_1
XFILLER_6_309 vssd1 vssd1 vccd1 vccd1 sky130_fd_sc_hd__decap_4
XTAP_TAPCELL_ROW_20_366 vssd1 vccd1 sky130_fd_sc_hd__tapvpwrvgnd_1
XFILLER_77_305 vssd1 vssd1 vccd1 vccd1 sky130_fd_sc_hd__fill_1
XANTENNA_fanout82_A _3460_/A1 vssd1 vssd1 vccd1 vccd1 sky130_fd_sc_hd__diode_2
XFILLER_73_500 vssd1 vssd1 vccd1 vccd1 sky130_fd_sc_hd__fill_2
XANTENNA__3879__S _3928_/S vssd1 vssd1 vccd1 vccd1 sky130_fd_sc_hd__diode_2
XFILLER_18_449 vccd1 vssd1 vccd1 vssd1 sky130_ef_sc_hd__decap_12
XFILLER_45_235 vccd1 vssd1 vccd1 vssd1 sky130_ef_sc_hd__decap_12
XFILLER_26_51 vccd1 vssd1 vccd1 vssd1 sky130_ef_sc_hd__decap_12
XTAP_TAPCELL_ROW_28_444 vssd1 vccd1 sky130_fd_sc_hd__tapvpwrvgnd_1
XFILLER_33_419 vccd1 vssd1 vccd1 vssd1 sky130_ef_sc_hd__decap_12
XFILLER_45_279 vssd1 vssd1 vccd1 vccd1 sky130_fd_sc_hd__fill_1
XFILLER_13_121 vssd1 vssd1 vccd1 vccd1 sky130_fd_sc_hd__decap_6
XANTENNA__4800__Q _4800_/Q vssd1 vssd1 vccd1 vccd1 sky130_fd_sc_hd__diode_2
XANTENNA__4013__A_N _4100_/C vssd1 vssd1 vccd1 vccd1 sky130_fd_sc_hd__diode_2
XFILLER_68_305 vssd1 vssd1 vccd1 vccd1 sky130_fd_sc_hd__decap_3
XFILLER_3_55 vssd1 vssd1 vccd1 vccd1 sky130_fd_sc_hd__fill_1
X_3010_ _4764_/Q _4779_/Q _3033_/A _2978_/B _3009_/B vssd1 vssd1 vccd1 vccd1 _3010_/X
+ sky130_fd_sc_hd__a311o_1
XFILLER_36_224 vssd1 vssd1 vccd1 vccd1 sky130_fd_sc_hd__decap_6
XFILLER_24_419 vssd1 vssd1 vccd1 vccd1 sky130_fd_sc_hd__fill_1
XTAP_TAPCELL_ROW_62_745 vssd1 vccd1 sky130_fd_sc_hd__tapvpwrvgnd_1
X_3912_ _3995_/B2 _4173_/A2 _3911_/Y vssd1 vssd1 vccd1 vccd1 _4662_/D sky130_fd_sc_hd__a21oi_1
X_3843_ _3001_/X _3013_/Y _3014_/Y vssd1 vssd1 vccd1 vccd1 _3843_/Y sky130_fd_sc_hd__a21oi_1
X_3774_ _3774_/A _3774_/B vssd1 vssd1 vccd1 vccd1 _3774_/Y sky130_fd_sc_hd__xnor2_1
X_2725_ _2725_/A _2725_/B vssd1 vssd1 vccd1 vccd1 _3825_/B sky130_fd_sc_hd__and2_1
X_2656_ hold155/X _3870_/B1 _2655_/Y vssd1 vssd1 vccd1 vccd1 _4521_/D sky130_fd_sc_hd__o21a_1
Xclkbuf_leaf_8_clk clkload1/A vssd1 vssd1 vccd1 vccd1 _4771_/CLK sky130_fd_sc_hd__clkbuf_8
XANTENNA__4153__A2 _4176_/A2 vssd1 vssd1 vccd1 vccd1 sky130_fd_sc_hd__diode_2
X_2587_ _2588_/A _2588_/B _2588_/C _2588_/D vssd1 vssd1 vccd1 vccd1 _2621_/B sky130_fd_sc_hd__a22oi_4
Xfanout104 _3534_/A2 vssd1 vssd1 vccd1 vccd1 _3540_/B2 sky130_fd_sc_hd__buf_2
Xfanout115 _2797_/A2 vssd1 vssd1 vccd1 vccd1 _2565_/B2 sky130_fd_sc_hd__buf_1
Xfanout126 _2274_/Y vssd1 vssd1 vccd1 vccd1 _3890_/S sky130_fd_sc_hd__clkbuf_2
Xfanout137 fanout141/X vssd1 vssd1 vccd1 vccd1 _4193_/B2 sky130_fd_sc_hd__clkbuf_2
X_4326_ _4774_/Q _4338_/A2 _4323_/X _4325_/X vssd1 vssd1 vccd1 vccd1 _4774_/D sky130_fd_sc_hd__o22a_1
Xfanout159 _4241_/B2 vssd1 vssd1 vccd1 vccd1 _4369_/B1 sky130_fd_sc_hd__clkbuf_2
XANTENNA_fanout384_A fanout388/X vssd1 vssd1 vccd1 vccd1 sky130_fd_sc_hd__diode_2
Xfanout148 _4209_/B2 vssd1 vssd1 vccd1 vccd1 _4208_/B1 sky130_fd_sc_hd__buf_2
X_4257_ _4281_/A0 _4281_/A1 _4323_/S vssd1 vssd1 vccd1 vccd1 _4257_/X sky130_fd_sc_hd__mux2_1
X_4188_ _4320_/A _4212_/A2 _4192_/B1 vssd1 vssd1 vccd1 vccd1 _4188_/Y sky130_fd_sc_hd__o21ai_1
X_3208_ _4558_/Q _4599_/Q _4598_/Q _4557_/Q vssd1 vssd1 vccd1 vccd1 _3208_/Y sky130_fd_sc_hd__a22oi_1
X_3139_ _4537_/Q _3156_/B1 _3126_/X _3138_/Y vssd1 vssd1 vccd1 vccd1 _4537_/D sky130_fd_sc_hd__o22a_1
XFILLER_82_363 vssd1 vssd1 vccd1 vccd1 sky130_fd_sc_hd__fill_1
XANTENNA_fanout172_X _4020_/A1 vssd1 vssd1 vccd1 vccd1 sky130_fd_sc_hd__diode_2
XFILLER_82_385 vssd1 vssd1 vccd1 vccd1 sky130_fd_sc_hd__decap_3
XTAP_TAPCELL_ROW_25_414 vssd1 vccd1 sky130_fd_sc_hd__tapvpwrvgnd_1
XANTENNA__4377__C1 _4377_/C1 vssd1 vssd1 vccd1 vccd1 sky130_fd_sc_hd__diode_2
XFILLER_10_124 vssd1 vssd1 vccd1 vccd1 sky130_fd_sc_hd__fill_1
XANTENNA__4323__S _4323_/S vssd1 vssd1 vccd1 vccd1 sky130_fd_sc_hd__diode_2
Xhold180 _4454_/Q vssd1 vssd1 vccd1 vccd1 hold180/X sky130_fd_sc_hd__dlygate4sd3_1
XFILLER_77_113 vssd1 vssd1 vccd1 vccd1 sky130_fd_sc_hd__fill_2
XPHY_EDGE_ROW_0_Left_88 vssd1 vssd1 vccd1 vccd1 sky130_fd_sc_hd__decap_3
Xhold191 _4525_/Q vssd1 vssd1 vccd1 vccd1 hold191/X sky130_fd_sc_hd__dlygate4sd3_1
XFILLER_77_124 vccd1 vssd1 vccd1 vssd1 sky130_ef_sc_hd__decap_12
XFILLER_18_257 vssd1 vssd1 vccd1 vccd1 sky130_fd_sc_hd__fill_1
XANTENNA__3407__A1 _3423_/A1 vssd1 vssd1 vccd1 vccd1 sky130_fd_sc_hd__diode_2
XFILLER_53_71 vssd1 vssd1 vccd1 vccd1 sky130_fd_sc_hd__fill_2
XFILLER_41_293 vssd1 vssd1 vccd1 vccd1 sky130_fd_sc_hd__fill_1
XFILLER_53_93 vssd1 vssd1 vccd1 vccd1 sky130_fd_sc_hd__fill_2
X_3490_ _4569_/Q _3522_/A2 _3488_/X _3489_/X vssd1 vssd1 vccd1 vccd1 _4569_/D sky130_fd_sc_hd__a22o_1
X_2510_ _4516_/Q _2565_/B2 _2509_/Y vssd1 vssd1 vccd1 vccd1 _4516_/D sky130_fd_sc_hd__o21a_1
X_2441_ _4511_/Q _3806_/A2 _2440_/Y vssd1 vssd1 vccd1 vccd1 _4511_/D sky130_fd_sc_hd__o21a_1
X_2372_ hold2/X _2371_/X _2382_/S vssd1 vssd1 vccd1 vccd1 _4481_/D sky130_fd_sc_hd__mux2_1
X_4111_ _4172_/B _4168_/C _4223_/D vssd1 vssd1 vccd1 vccd1 _4111_/Y sky130_fd_sc_hd__o21bai_1
X_4042_ _4702_/Q _3975_/S _4041_/Y _4040_/X vssd1 vssd1 vccd1 vccd1 _4702_/D sky130_fd_sc_hd__a22o_1
XTAP_TAPCELL_ROW_39_539 vssd1 vccd1 sky130_fd_sc_hd__tapvpwrvgnd_1
XANTENNA__4408__S _4408_/S vssd1 vssd1 vccd1 vccd1 sky130_fd_sc_hd__diode_2
XFILLER_64_363 vssd1 vssd1 vccd1 vccd1 sky130_fd_sc_hd__fill_1
XFILLER_64_396 vssd1 vssd1 vccd1 vccd1 sky130_fd_sc_hd__decap_8
XFILLER_32_282 vssd1 vssd1 vccd1 vccd1 sky130_fd_sc_hd__fill_1
X_3826_ hold171/X _3828_/A2 _3825_/X _2726_/Y vssd1 vssd1 vccd1 vccd1 _4631_/D sky130_fd_sc_hd__a22o_1
XANTENNA__4143__S _4215_/C vssd1 vssd1 vccd1 vccd1 sky130_fd_sc_hd__diode_2
X_3757_ _3755_/X _3756_/Y _3549_/A vssd1 vssd1 vccd1 vccd1 _3757_/Y sky130_fd_sc_hd__o21ai_1
XTAP_TAPCELL_ROW_30_461 vssd1 vccd1 sky130_fd_sc_hd__tapvpwrvgnd_1
XPHY_EDGE_ROW_18_Left_106 vssd1 vssd1 vccd1 vccd1 sky130_fd_sc_hd__decap_3
X_2708_ _4742_/Q hold99/A vssd1 vssd1 vccd1 vccd1 _2709_/B sky130_fd_sc_hd__nor2_1
X_3688_ _3676_/Y _3727_/B _3687_/Y vssd1 vssd1 vccd1 vccd1 _3689_/A sky130_fd_sc_hd__o21a_1
X_2639_ _2688_/A _2638_/B _2637_/Y vssd1 vssd1 vccd1 vccd1 _2640_/B sky130_fd_sc_hd__a21bo_1
XFILLER_87_411 vssd1 vssd1 vccd1 vccd1 sky130_fd_sc_hd__decap_8
XANTENNA__3885__A1 _4136_/B vssd1 vssd1 vccd1 vccd1 sky130_fd_sc_hd__diode_2
X_4309_ _4246_/C _4245_/D _4246_/B _4238_/S vssd1 vssd1 vccd1 vccd1 _4309_/X sky130_fd_sc_hd__a22o_1
XFILLER_87_477 vssd1 vssd1 vccd1 vccd1 sky130_fd_sc_hd__fill_2
XFILLER_47_319 vssd1 vssd1 vccd1 vccd1 sky130_fd_sc_hd__decap_8
XFILLER_74_37 vssd1 vssd1 vccd1 vccd1 sky130_fd_sc_hd__decap_6
XPHY_EDGE_ROW_27_Left_115 vssd1 vssd1 vccd1 vccd1 sky130_fd_sc_hd__decap_3
XFILLER_43_514 vssd1 vssd1 vccd1 vccd1 sky130_fd_sc_hd__fill_1
XFILLER_55_374 vssd1 vssd1 vccd1 vccd1 sky130_fd_sc_hd__fill_1
XFILLER_30_208 vssd1 vssd1 vccd1 vccd1 sky130_fd_sc_hd__decap_4
XFILLER_11_466 vccd1 vssd1 vccd1 vssd1 sky130_ef_sc_hd__decap_12
XPHY_EDGE_ROW_36_Left_124 vssd1 vssd1 vccd1 vccd1 sky130_fd_sc_hd__decap_3
XANTENNA__4117__A2 _4173_/A2 vssd1 vssd1 vccd1 vccd1 sky130_fd_sc_hd__diode_2
XFILLER_2_153 vssd1 vssd1 vccd1 vccd1 sky130_fd_sc_hd__decap_3
XFILLER_78_477 vssd1 vssd1 vccd1 vccd1 sky130_fd_sc_hd__decap_3
XFILLER_65_105 vssd1 vssd1 vccd1 vccd1 sky130_fd_sc_hd__decap_6
XPHY_EDGE_ROW_45_Left_133 vssd1 vssd1 vccd1 vccd1 sky130_fd_sc_hd__decap_3
XANTENNA__2300__A1 _4064_/D vssd1 vssd1 vccd1 vccd1 sky130_fd_sc_hd__diode_2
XANTENNA__2537__A _4737_/Q vssd1 vssd1 vccd1 vccd1 sky130_fd_sc_hd__diode_2
XFILLER_61_300 vccd1 vssd1 vccd1 vssd1 sky130_ef_sc_hd__decap_12
XTAP_TAPCELL_ROW_36_509 vssd1 vccd1 sky130_fd_sc_hd__tapvpwrvgnd_1
XFILLER_46_374 vssd1 vssd1 vccd1 vccd1 sky130_fd_sc_hd__fill_1
XTAP_TAPCELL_ROW_72_840 vssd1 vccd1 sky130_fd_sc_hd__tapvpwrvgnd_1
XFILLER_64_81 vssd1 vssd1 vccd1 vccd1 sky130_fd_sc_hd__fill_1
X_2990_ _3049_/B _4751_/Q vssd1 vssd1 vccd1 vccd1 _2993_/C sky130_fd_sc_hd__and2_1
XANTENNA__4053__A1 _4120_/D vssd1 vssd1 vccd1 vccd1 sky130_fd_sc_hd__diode_2
XTAP_TAPCELL_ROW_44_586 vssd1 vccd1 sky130_fd_sc_hd__tapvpwrvgnd_1
X_4660_ _4687_/CLK _4660_/D fanout384/X vssd1 vssd1 vccd1 vccd1 _4660_/Q sky130_fd_sc_hd__dfrtp_2
XFILLER_9_65 vssd1 vssd1 vccd1 vccd1 sky130_fd_sc_hd__decap_4
XPHY_EDGE_ROW_54_Left_142 vssd1 vssd1 vccd1 vccd1 sky130_fd_sc_hd__decap_3
X_3611_ _3607_/Y _3609_/Y _3605_/Y vssd1 vssd1 vccd1 vccd1 _3611_/Y sky130_fd_sc_hd__a21oi_1
X_4591_ _4593_/CLK _4591_/D fanout409/X vssd1 vssd1 vccd1 vccd1 _4591_/Q sky130_fd_sc_hd__dfrtp_1
X_3542_ _3613_/C _3613_/B vssd1 vssd1 vccd1 vccd1 _3542_/X sky130_fd_sc_hd__and2_1
X_3473_ _3301_/C _3178_/Y _3300_/X _3463_/A vssd1 vssd1 vccd1 vccd1 _3474_/B sky130_fd_sc_hd__o22ai_2
X_2424_ hold17/X _2423_/X _2424_/S vssd1 vssd1 vccd1 vccd1 _4507_/D sky130_fd_sc_hd__mux2_1
X_2355_ _4545_/Q hold25/A _2365_/S vssd1 vssd1 vccd1 vccd1 _2355_/X sky130_fd_sc_hd__mux2_1
XFILLER_69_466 vssd1 vssd1 vccd1 vccd1 sky130_fd_sc_hd__decap_3
XPHY_EDGE_ROW_63_Left_151 vssd1 vssd1 vccd1 vccd1 sky130_fd_sc_hd__decap_3
XFILLER_28_19 vssd1 vssd1 vccd1 vccd1 sky130_fd_sc_hd__fill_1
XFILLER_84_414 vssd1 vssd1 vccd1 vccd1 sky130_fd_sc_hd__decap_6
X_2286_ _3875_/A0 _2310_/A1 _3984_/S vssd1 vssd1 vccd1 vccd1 _2286_/X sky130_fd_sc_hd__mux2_1
X_4025_ _4104_/C _4037_/B _4037_/C _4087_/S vssd1 vssd1 vccd1 vccd1 _4025_/X sky130_fd_sc_hd__and4b_1
XFILLER_37_330 vssd1 vssd1 vccd1 vccd1 sky130_fd_sc_hd__decap_6
XFILLER_25_514 vssd1 vssd1 vccd1 vccd1 sky130_fd_sc_hd__fill_1
XFILLER_37_385 vssd1 vssd1 vccd1 vccd1 sky130_fd_sc_hd__decap_6
XANTENNA__4084__D _4219_/C vssd1 vssd1 vccd1 vccd1 sky130_fd_sc_hd__diode_2
XANTENNA_fanout347_A _4316_/A vssd1 vssd1 vccd1 vccd1 sky130_fd_sc_hd__diode_2
XFILLER_52_377 vssd1 vssd1 vccd1 vccd1 sky130_fd_sc_hd__decap_8
XPHY_EDGE_ROW_72_Left_160 vssd1 vssd1 vccd1 vccd1 sky130_fd_sc_hd__decap_3
X_3809_ _3809_/A _3809_/B vssd1 vssd1 vccd1 vccd1 _3809_/Y sky130_fd_sc_hd__nand2_1
X_4789_ _4794_/CLK _4789_/D fanout375/X vssd1 vssd1 vccd1 vccd1 _4789_/Q sky130_fd_sc_hd__dfrtp_1
XANTENNA_fanout302_X _4368_/A vssd1 vssd1 vccd1 vccd1 sky130_fd_sc_hd__diode_2
XTAP_TAPCELL_ROW_7_256 vssd1 vccd1 sky130_fd_sc_hd__tapvpwrvgnd_1
XTAP_TAPCELL_ROW_86_965 vssd1 vccd1 sky130_fd_sc_hd__tapvpwrvgnd_1
XFILLER_85_69 vssd1 vssd1 vccd1 vccd1 sky130_fd_sc_hd__decap_8
XFILLER_62_108 vssd1 vssd1 vccd1 vccd1 sky130_fd_sc_hd__fill_1
XFILLER_16_514 vssd1 vssd1 vccd1 vccd1 sky130_fd_sc_hd__fill_1
XFILLER_28_363 vssd1 vssd1 vccd1 vccd1 sky130_fd_sc_hd__fill_1
XFILLER_43_322 vssd1 vssd1 vccd1 vccd1 sky130_fd_sc_hd__decap_3
XFILLER_43_377 vccd1 vssd1 vccd1 vssd1 sky130_ef_sc_hd__decap_12
XANTENNA__3794__A0 _3794_/A0 vssd1 vssd1 vccd1 vccd1 sky130_fd_sc_hd__diode_2
XTAP_TAPCELL_ROW_41_556 vssd1 vccd1 sky130_fd_sc_hd__tapvpwrvgnd_1
XANTENNA__4338__A2 _4338_/A2 vssd1 vssd1 vccd1 vccd1 sky130_fd_sc_hd__diode_2
XFILLER_3_473 vccd1 vssd1 vccd1 vssd1 sky130_ef_sc_hd__decap_12
XPHY_EDGE_ROW_3_Left_91 vssd1 vssd1 vccd1 vccd1 sky130_fd_sc_hd__decap_3
XFILLER_38_138 vssd1 vssd1 vccd1 vccd1 sky130_fd_sc_hd__fill_2
XTAP_TAPCELL_ROW_49_634 vssd1 vccd1 sky130_fd_sc_hd__tapvpwrvgnd_1
XANTENNA__4026__A1 _4087_/S vssd1 vssd1 vccd1 vccd1 sky130_fd_sc_hd__diode_2
X_2973_ _4734_/Q _2939_/B _2938_/A vssd1 vssd1 vccd1 vccd1 _2977_/A sky130_fd_sc_hd__a21o_1
X_4712_ _4745_/CLK _4712_/D fanout389/X vssd1 vssd1 vccd1 vccd1 hold99/A sky130_fd_sc_hd__dfrtp_1
X_4643_ _4644_/CLK _4643_/D fanout428/X vssd1 vssd1 vccd1 vccd1 _4643_/Q sky130_fd_sc_hd__dfrtp_1
X_4574_ _4577_/CLK _4574_/D fanout437/X vssd1 vssd1 vccd1 vccd1 _4574_/Q sky130_fd_sc_hd__dfrtp_1
X_3525_ _3507_/A _3523_/X _3524_/Y _3525_/B1 vssd1 vssd1 vccd1 vccd1 _3525_/Y sky130_fd_sc_hd__a31oi_1
X_3456_ _4563_/Q _3540_/B2 _3454_/X _3455_/X vssd1 vssd1 vccd1 vccd1 _4563_/D sky130_fd_sc_hd__a22o_1
X_2407_ _4571_/Q hold89/A _2421_/S vssd1 vssd1 vccd1 vccd1 _2407_/X sky130_fd_sc_hd__mux2_1
XANTENNA_fanout297_A _4803_/Q vssd1 vssd1 vccd1 vccd1 sky130_fd_sc_hd__diode_2
X_3387_ _3241_/A _3241_/B _3386_/X vssd1 vssd1 vccd1 vccd1 _3387_/Y sky130_fd_sc_hd__o21ai_1
XTAP_TAPCELL_ROW_4_226 vssd1 vccd1 sky130_fd_sc_hd__tapvpwrvgnd_1
X_2338_ _4037_/D _2338_/B vssd1 vssd1 vccd1 vccd1 _2338_/Y sky130_fd_sc_hd__nor2_1
XFILLER_57_425 vssd1 vssd1 vccd1 vccd1 sky130_fd_sc_hd__decap_3
XFILLER_57_436 vccd1 vssd1 vccd1 vssd1 sky130_ef_sc_hd__decap_12
X_2269_ hold40/X _4577_/Q _2270_/S vssd1 vssd1 vccd1 vccd1 _4448_/D sky130_fd_sc_hd__mux2_1
X_4008_ _4036_/A0 _4036_/A1 _4075_/S vssd1 vssd1 vccd1 vccd1 _4008_/X sky130_fd_sc_hd__mux2_1
XTAP_TAPCELL_ROW_83_935 vssd1 vccd1 sky130_fd_sc_hd__tapvpwrvgnd_1
XFILLER_25_311 vssd1 vssd1 vccd1 vccd1 sky130_fd_sc_hd__fill_1
XFILLER_80_472 vssd1 vssd1 vccd1 vccd1 sky130_fd_sc_hd__decap_4
XFILLER_71_38 vssd1 vssd1 vccd1 vccd1 sky130_fd_sc_hd__fill_2
XFILLER_71_49 vssd1 vssd1 vccd1 vccd1 sky130_fd_sc_hd__decap_4
XFILLER_0_421 vssd1 vssd1 vccd1 vccd1 sky130_fd_sc_hd__fill_1
Xhold40 hold40/A vssd1 vssd1 vccd1 vccd1 hold40/X sky130_fd_sc_hd__dlygate4sd3_1
XFILLER_0_465 vssd1 vssd1 vccd1 vccd1 sky130_fd_sc_hd__decap_8
Xhold62 hold62/A vssd1 vssd1 vccd1 vccd1 hold62/X sky130_fd_sc_hd__dlygate4sd3_1
XANTENNA_input25_A s_axis_tdata[2] vssd1 vssd1 vccd1 vccd1 sky130_fd_sc_hd__diode_2
Xhold51 hold51/A vssd1 vssd1 vccd1 vccd1 hold51/X sky130_fd_sc_hd__dlygate4sd3_1
Xhold73 hold73/A vssd1 vssd1 vccd1 vccd1 hold73/X sky130_fd_sc_hd__dlygate4sd3_1
XFILLER_75_277 vssd1 vssd1 vccd1 vccd1 sky130_fd_sc_hd__decap_3
Xhold84 hold84/A vssd1 vssd1 vccd1 vccd1 hold84/X sky130_fd_sc_hd__dlygate4sd3_1
XFILLER_63_417 vssd1 vssd1 vccd1 vccd1 sky130_fd_sc_hd__decap_8
XTAP_TAPCELL_ROW_46_604 vssd1 vccd1 sky130_fd_sc_hd__tapvpwrvgnd_1
Xhold95 hold95/A vssd1 vssd1 vccd1 vccd1 hold95/X sky130_fd_sc_hd__dlygate4sd3_1
XFILLER_28_193 vssd1 vssd1 vccd1 vccd1 sky130_fd_sc_hd__decap_3
XFILLER_16_377 vccd1 vssd1 vccd1 vssd1 sky130_ef_sc_hd__decap_12
XANTENNA__4803__Q _4803_/Q vssd1 vssd1 vccd1 vccd1 sky130_fd_sc_hd__diode_2
X_3310_ _4575_/Q _3311_/B vssd1 vssd1 vccd1 vccd1 _3524_/B sky130_fd_sc_hd__nand2_1
X_4290_ _4245_/D _4306_/B _4302_/C _4356_/A vssd1 vssd1 vccd1 vccd1 _4290_/X sky130_fd_sc_hd__and4b_1
XFILLER_3_281 vssd1 vssd1 vccd1 vccd1 sky130_fd_sc_hd__fill_1
X_3241_ _3241_/A _3241_/B vssd1 vssd1 vccd1 vccd1 _3284_/B sky130_fd_sc_hd__nor2_1
X_3172_ _4569_/Q _4610_/Q vssd1 vssd1 vccd1 vccd1 _3491_/A sky130_fd_sc_hd__nand2_1
XFILLER_66_211 vssd1 vssd1 vccd1 vccd1 sky130_fd_sc_hd__decap_3
XFILLER_20_3 vssd1 vssd1 vccd1 vccd1 sky130_fd_sc_hd__decap_4
XFILLER_39_447 vssd1 vssd1 vccd1 vccd1 sky130_fd_sc_hd__fill_1
XANTENNA_clkbuf_leaf_6_clk_A clkload1/A vssd1 vssd1 vccd1 vccd1 sky130_fd_sc_hd__diode_2
XANTENNA__4247__A1 _4313_/S vssd1 vssd1 vccd1 vccd1 sky130_fd_sc_hd__diode_2
XFILLER_81_225 vccd1 vssd1 vccd1 vssd1 sky130_ef_sc_hd__decap_12
XANTENNA__3455__C1 _3923_/A vssd1 vssd1 vccd1 vccd1 sky130_fd_sc_hd__diode_2
XTAP_TAPCELL_ROW_80_905 vssd1 vccd1 sky130_fd_sc_hd__tapvpwrvgnd_1
XFILLER_34_141 vssd1 vssd1 vccd1 vccd1 sky130_fd_sc_hd__decap_4
X_2956_ _4530_/Q _2985_/A2 _2943_/X _2955_/Y vssd1 vssd1 vccd1 vccd1 _4530_/D sky130_fd_sc_hd__o22a_1
X_2887_ _2857_/A _2857_/B _2857_/C vssd1 vssd1 vccd1 vccd1 _2896_/A sky130_fd_sc_hd__a21boi_1
XANTENNA__4151__S _4223_/C vssd1 vssd1 vccd1 vccd1 sky130_fd_sc_hd__diode_2
X_4626_ _4631_/CLK _4626_/D fanout410/X vssd1 vssd1 vccd1 vccd1 _4626_/Q sky130_fd_sc_hd__dfrtp_1
X_4557_ _4667_/CLK _4557_/D fanout423/X vssd1 vssd1 vccd1 vccd1 _4557_/Q sky130_fd_sc_hd__dfrtp_2
X_3508_ _3505_/Y _3507_/Y _3525_/B1 vssd1 vssd1 vccd1 vccd1 _3508_/Y sky130_fd_sc_hd__o21bai_1
XANTENNA__3930__B1 _3975_/S vssd1 vssd1 vccd1 vccd1 sky130_fd_sc_hd__diode_2
XFILLER_1_229 vssd1 vssd1 vccd1 vccd1 sky130_fd_sc_hd__fill_1
XFILLER_1_218 vssd1 vssd1 vccd1 vccd1 sky130_fd_sc_hd__decap_6
X_4488_ _4562_/CLK _4488_/D fanout432/X vssd1 vssd1 vccd1 vccd1 hold32/A sky130_fd_sc_hd__dfrtp_1
X_3439_ _4601_/Q _3504_/A2 _3477_/B1 _3923_/A vssd1 vssd1 vccd1 vccd1 _3439_/X sky130_fd_sc_hd__o211a_1
XFILLER_57_299 vssd1 vssd1 vccd1 vccd1 sky130_fd_sc_hd__fill_1
XFILLER_82_15 vccd1 vssd1 vccd1 vssd1 sky130_ef_sc_hd__decap_12
XFILLER_13_325 vssd1 vssd1 vccd1 vccd1 sky130_fd_sc_hd__decap_8
XFILLER_25_185 vssd1 vssd1 vccd1 vccd1 sky130_fd_sc_hd__decap_6
XFILLER_53_461 vssd1 vssd1 vccd1 vccd1 sky130_fd_sc_hd__fill_1
XANTENNA__3461__A2 _3504_/A2 vssd1 vssd1 vccd1 vccd1 sky130_fd_sc_hd__diode_2
XFILLER_15_75 vssd1 vssd1 vccd1 vccd1 sky130_fd_sc_hd__decap_4
XTAP_TAPCELL_ROW_51_651 vssd1 vccd1 sky130_fd_sc_hd__tapvpwrvgnd_1
XTAP_TAPCELL_ROW_23_397 vssd1 vccd1 sky130_fd_sc_hd__tapvpwrvgnd_1
XFILLER_5_513 vssd1 vssd1 vccd1 vccd1 sky130_fd_sc_hd__fill_2
Xoutput41 hold9/A vssd1 vssd1 vccd1 vccd1 m_axis_tdata[13] sky130_fd_sc_hd__buf_2
Xoutput52 hold70/A vssd1 vssd1 vccd1 vccd1 m_axis_tdata[23] sky130_fd_sc_hd__buf_2
Xoutput63 hold84/A vssd1 vssd1 vccd1 vccd1 m_axis_tdata[33] sky130_fd_sc_hd__buf_2
Xoutput74 hold4/A vssd1 vssd1 vccd1 vccd1 m_axis_tdata[7] sky130_fd_sc_hd__buf_2
XFILLER_0_273 vssd1 vssd1 vccd1 vccd1 sky130_fd_sc_hd__decap_6
XFILLER_48_299 vssd1 vssd1 vccd1 vccd1 sky130_fd_sc_hd__fill_1
XANTENNA__3988__A0 _4020_/A0 vssd1 vssd1 vccd1 vccd1 sky130_fd_sc_hd__diode_2
XFILLER_16_141 vccd1 vssd1 vccd1 vssd1 sky130_ef_sc_hd__decap_12
X_3790_ _3778_/Y _3781_/Y _3787_/X _3788_/X vssd1 vssd1 vccd1 vccd1 _3791_/B sky130_fd_sc_hd__o2bb2ai_1
XFILLER_31_155 vccd1 vssd1 vccd1 vssd1 sky130_ef_sc_hd__decap_12
X_2810_ _2810_/A _2810_/B vssd1 vssd1 vccd1 vccd1 _2811_/B sky130_fd_sc_hd__nor2_1
XFILLER_12_380 vssd1 vssd1 vccd1 vccd1 sky130_fd_sc_hd__decap_3
X_2741_ _4743_/Q _4713_/Q vssd1 vssd1 vccd1 vccd1 _2743_/C sky130_fd_sc_hd__nand2_2
X_4411_ hold67/X input35/X _4411_/S vssd1 vssd1 vccd1 vccd1 _4820_/D sky130_fd_sc_hd__mux2_1
X_2672_ _2672_/A _2672_/B vssd1 vssd1 vccd1 vccd1 _2673_/B sky130_fd_sc_hd__nor2_1
X_4342_ _4778_/Q _2273_/X _4339_/X _4341_/X vssd1 vssd1 vccd1 vccd1 _4778_/D sky130_fd_sc_hd__o22a_1
Xfanout308 _4360_/A vssd1 vssd1 vccd1 vccd1 _4227_/C sky130_fd_sc_hd__buf_2
Xfanout319 _4796_/Q vssd1 vssd1 vccd1 vccd1 _3950_/A2 sky130_fd_sc_hd__buf_2
X_4273_ _4281_/A0 _4281_/A1 _4273_/S vssd1 vssd1 vccd1 vccd1 _4273_/X sky130_fd_sc_hd__mux2_1
X_3224_ _4555_/Q _4596_/Q vssd1 vssd1 vccd1 vccd1 _3225_/B sky130_fd_sc_hd__nor2_1
.ends
